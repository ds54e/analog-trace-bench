.subckt DUT VIN VOUT VSS VREF
CFAS G VOUT 10p
CMIR VOUT MIR 1.15p
RBIAS PB VSS 30k
RBLEED VOUT VSS 33k
RFBBOT FB VSS 500k
RFBTOP VOUT FB 1.503meg
RREFBOT RP VSS 500k
RREFTOP VREF RP 500k
XNBIAS MIR MIR VSS VSS sky130_fd_pr__nfet_01v8 l=0.5 w=10
XNDRV G X VSS VSS sky130_fd_pr__nfet_01v8 l=0.5 w=10
XNMIR X MIR VSS VSS sky130_fd_pr__nfet_01v8 l=0.5 w=10
XPASS VOUT G VIN VIN sky130_fd_pr__pfet_01v8 l=0.15 w=100 m=4
XPBIAS PB PB VIN VIN sky130_fd_pr__pfet_01v8 l=0.15 w=5
XPFB X FB TAIL VIN sky130_fd_pr__pfet_01v8 l=0.19 w=38
XPPULL G PB VIN VIN sky130_fd_pr__pfet_01v8 l=0.15 w=3.6
XPREF MIR RP TAIL VIN sky130_fd_pr__pfet_01v8 l=0.19 w=38
XPTAIL TAIL PB VIN VIN sky130_fd_pr__pfet_01v8 l=0.15 w=10
.ends DUT
