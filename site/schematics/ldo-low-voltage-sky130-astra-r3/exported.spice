.subckt DUT VIN VOUT VSS VREF
CC CZ VOUT 4p
CFF VOUT FB 10p
CR REF VSS 5p
RB VIN NB 130k
RFB1 VOUT FB 117.6k
RFB2 FB VSS 30k
RR1 VREF REF 900k
RR2 REF VSS 600k
RZ GATE CZ 20k
XN1 N1 N1 VSS VSS sky130_fd_pr__nfet_01v8 l=1 w=50 nf=1 m=1
XN2 N2 N2 VSS VSS sky130_fd_pr__nfet_01v8 l=1 w=50 nf=1 m=1
XN3 GATE N1 VSS VSS sky130_fd_pr__nfet_01v8 l=1 w=50 nf=1 m=1
XN4 P1 N2 VSS VSS sky130_fd_pr__nfet_01v8 l=1 w=50 nf=1 m=1
XNB NB NB VSS VSS sky130_fd_pr__nfet_01v8 l=1 w=20 nf=1 m=1
XNB2 PB NB VSS VSS sky130_fd_pr__nfet_01v8 l=1 w=20 nf=1 m=1
XP1 P1 P1 VIN VIN sky130_fd_pr__pfet_01v8 l=0.5 w=50 nf=1 m=2
XP2 GATE P1 VIN VIN sky130_fd_pr__pfet_01v8 l=0.5 w=50 nf=1 m=2
XPASS VOUT GATE VIN VIN sky130_fd_pr__pfet_01v8 l=0.15 w=100 nf=1 m=4
XPB PB PB VIN VIN sky130_fd_pr__pfet_01v8 l=1 w=100 nf=1 m=1
XPI1 N1 FB TAIL VIN sky130_fd_pr__pfet_01v8 l=0.5 w=100 nf=1 m=8
XPI2 N2 REF TAIL VIN sky130_fd_pr__pfet_01v8 l=0.5 w=100 nf=1 m=8
XPT TAIL PB VIN VIN sky130_fd_pr__pfet_01v8 l=1 w=100 nf=1 m=6
.ends DUT
