* Two-stage Miller OTA, NMOS input pair, PMOS CS second stage
.subckt DUT VINP VINN VOUT VDD VSS IBIAS
XMB IBIAS IBIAS VSS VSS sky130_fd_pr__nfet_01v8 W=20 L=1 nf=1 m=1
XMT tail IBIAS VSS VSS sky130_fd_pr__nfet_01v8 W=20 L=1 nf=1 m=6
XM1 n1 VINP tail VSS sky130_fd_pr__nfet_01v8 W=50 L=1 nf=1 m=2
XM2 dm VINN tail VSS sky130_fd_pr__nfet_01v8 W=50 L=1 nf=1 m=2
XM3 dm dm VDD VDD sky130_fd_pr__pfet_01v8 W=60 L=0.5 nf=1 m=1
XM4 n1 dm VDD VDD sky130_fd_pr__pfet_01v8 W=60 L=0.5 nf=1 m=1
XM6 VOUT n1 VDD VDD sky130_fd_pr__pfet_01v8 W=60 L=0.5 nf=1 m=6
XM7 VOUT IBIAS VSS VSS sky130_fd_pr__nfet_01v8 W=20 L=1 nf=1 m=18
RZ n1 nc 1000
CC nc VOUT 3e-12
.ends DUT
