* OTA-WIDE-SKY130 v7 : complementary input, NMOS bottom mirror, PMOS current
* source loads, NMOS CS 2nd stage, 60uA output stage
.subckt DUT VINP VINN VOUT VDD VSS IBIAS

* ---- bias from IBIAS (10uA into diode) ----
Xm20 IBIAS IBIAS VSS VSS sky130_fd_pr__nfet_01v8 W=20 L=1 nf=1 m=1
Xm21 ntail IBIAS VSS VSS sky130_fd_pr__nfet_01v8 W=20 L=1 nf=1 m=4
Xm22 pbiasb IBIAS VSS VSS sky130_fd_pr__nfet_01v8 W=20 L=1 nf=1 m=1
Xm23 pbiasb pbiasb VDD VDD sky130_fd_pr__pfet_01v8 W=40 L=2 nf=1 m=1
Xm26 ptailref IBIAS VSS VSS sky130_fd_pr__nfet_01v8 W=20 L=1 nf=1 m=1
Xm27 ptailref ptailref VDD VDD sky130_fd_pr__pfet_01v8 W=80 L=2 nf=1 m=1
Xm28 pbiaso IBIAS VSS VSS sky130_fd_pr__nfet_01v8 W=20 L=1 nf=1 m=1
Xm29 pbiaso pbiaso VDD VDD sky130_fd_pr__pfet_01v8 W=20 L=0.5 nf=1 m=1

* ---- current sources ----
Xm24 ptail ptailref VDD VDD sky130_fd_pr__pfet_01v8 W=80 L=2 nf=1 m=2
Xm25 VOUT pbiaso VDD VDD sky130_fd_pr__pfet_01v8 W=20 L=0.5 nf=1 m=12

* ---- N input pair: PMOS current-source loads, NMOS mirror to node B ----
Xm3 A pbiasb VDD VDD sky130_fd_pr__pfet_01v8 W=40 L=2 nf=1 m=3
Xm4 B pbiasb VDD VDD sky130_fd_pr__pfet_01v8 W=40 L=2 nf=1 m=3
Xm1 A VINN ntail VSS sky130_fd_pr__nfet_01v8 W=10 L=1 nf=1 m=28
Xm2 B VINP ntail VSS sky130_fd_pr__nfet_01v8 W=10 L=1 nf=1 m=28
Xm8 A A VSS VSS sky130_fd_pr__nfet_01v8 W=10 L=3 nf=1 m=1
Xm9 B A VSS VSS sky130_fd_pr__nfet_01v8 W=10 L=3 nf=1 m=1

* ---- P input pair with NMOS mirror to node B ----
Xm6 E VINN ptail VDD sky130_fd_pr__pfet_01v8 W=10 L=1 nf=1 m=28
Xm7 B VINP ptail VDD sky130_fd_pr__pfet_01v8 W=10 L=1 nf=1 m=28
Xm13 E E VSS VSS sky130_fd_pr__nfet_01v8 W=10 L=3 nf=1 m=1
Xm14 B E VSS VSS sky130_fd_pr__nfet_01v8 W=10 L=3 nf=1 m=1

* ---- second stage: NMOS common source ----
Xm11 VOUT B VSS VSS sky130_fd_pr__nfet_01v8 W=10 L=0.5 nf=1 m=2

* ---- Miller compensation ----
Rz B nz 1.5k
Cc nz VOUT 5p

.ends DUT
