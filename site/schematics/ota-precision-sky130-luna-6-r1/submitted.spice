.subckt DUT VINP VINN VOUT VDD VSS IBIAS
XMNREF IBIAS IBIAS VSS VSS sky130_fd_pr__nfet_01v8 W=100 L=2
XMNTAIL NTAIL IBIAS VSS VSS sky130_fd_pr__nfet_01v8 W=100 L=2 m=2
XMN1 N1 VINN NTAIL VSS sky130_fd_pr__nfet_01v8 W=100 L=5
XMN2 N2 VINP NTAIL VSS sky130_fd_pr__nfet_01v8 W=100 L=5
XMP3 N1 N1 VDD VDD sky130_fd_pr__pfet_01v8 W=100 L=0.8
XMP4 N2 N1 VDD VDD sky130_fd_pr__pfet_01v8 W=100 L=0.8
XMPBIAS PBIAS PBIAS VDD VDD sky130_fd_pr__pfet_01v8 W=30 L=2.5
XMNBIAS PBIAS IBIAS VSS VSS sky130_fd_pr__nfet_01v8 W=100 L=2
XMP5 VOUT PBIAS VDD VDD sky130_fd_pr__pfet_01v8 W=100 L=1.5 m=4
XMN5 VOUT N2 VSS VSS sky130_fd_pr__nfet_01v8 W=100 L=2.5 m=3
RCOMP VOUT NCOMP 1.8k
CCOMP NCOMP N2 11p
.ends DUT
