* generated
.subckt DUT VIN VOUT VSS VREF
XMP VOUT G VIN VIN sky130_fd_pr__pfet_01v8 W=1 L=0.35 nf=1 m=32
XMS BIAS G VIN VIN sky130_fd_pr__pfet_01v8 W=0.5 L=0.35 nf=1 m=1
RG VIN G 20000000.0
XMD G G VIN VIN sky130_fd_pr__pfet_01v8 W=0.42 L=10 nf=1 m=1
XM1 D VFB TAIL VSS sky130_fd_pr__nfet_01v8 W=24 L=0.25 nf=1 m=1
XM2 G VREF TAIL VSS sky130_fd_pr__nfet_01v8 W=24 L=0.25 nf=1 m=1
XM3 D D VIN VIN sky130_fd_pr__pfet_01v8 W=4 L=1 nf=1 m=1
XM4 G D VIN VIN sky130_fd_pr__pfet_01v8 W=4 L=1 nf=1 m=1
XM5 TAIL BIAS VSS VSS sky130_fd_pr__nfet_01v8 W=60 L=4 nf=1 m=1
XM6 BIAS BIAS VSS VSS sky130_fd_pr__nfet_01v8 W=60 L=4 nf=1 m=1
RB VIN BIAS 2800000.0
RT VOUT VFB 1007500.0
RBT VFB VSS 992500.0
CBIAS BIAS VSS 15p
.ends DUT
