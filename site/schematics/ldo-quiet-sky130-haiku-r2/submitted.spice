* LDO v5 variant
.subckt DUT VIN VOUT VSS VREF
XM1 N1 FB NT VSS sky130_fd_pr__nfet_01v8 W=100 L=2 nf=1 m=1
XM2 GATE VREF NT VSS sky130_fd_pr__nfet_01v8 W=100 L=2 nf=1 m=1
XM3 N1 N1 VIN VIN sky130_fd_pr__pfet_01v8 W=40 L=2 nf=1 m=1
XM4 GATE N1 VIN VIN sky130_fd_pr__pfet_01v8 W=40 L=2 nf=1 m=1
XM5 NT NB VSS VSS sky130_fd_pr__nfet_01v8 W=20 L=0.5 nf=1 m=1
XM6 NB NB VSS VSS sky130_fd_pr__nfet_01v8 W=10 L=0.5 nf=1 m=1
R1 VIN NB 100k
XMP VOUT GATE VIN VIN sky130_fd_pr__pfet_01v8 W=100 L=0.15 nf=1 m=4
R2 VOUT FB 15k
R3 FB VSS 15k
.ends DUT
