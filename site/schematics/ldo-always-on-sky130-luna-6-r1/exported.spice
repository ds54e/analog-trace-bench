.subckt DUT VIN VOUT VSS VREF
CCOMP NGATE VOUT 1p
CFF VOUT FB 1p
RBIAS VIN NBIAS 1.4meg
RFB1 VOUT FB 10meg
RFB2 FB VSS 10meg
XBIAS NBIAS NBIAS VSS VSS sky130_fd_pr__nfet_01v8 l=1 w=4
XINM NGATE VREF NTAIL VSS sky130_fd_pr__nfet_01v8 l=1 w=8
XINP NMIR FB NTAIL VSS sky130_fd_pr__nfet_01v8 l=1 w=8
XLOAD1 NMIR NMIR VIN VIN sky130_fd_pr__pfet_01v8 l=1 w=4
XLOAD2 NGATE NMIR VIN VIN sky130_fd_pr__pfet_01v8 l=1 w=4
XPASS VOUT NGATE VIN VIN sky130_fd_pr__pfet_01v8 l=0.25 w=100 m=4
XTAIL NTAIL NBIAS VSS VSS sky130_fd_pr__nfet_01v8 l=1 w=4
.ends DUT
