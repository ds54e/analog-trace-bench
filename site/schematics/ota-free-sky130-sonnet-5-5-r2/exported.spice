.subckt DUT VINP VINN VOUT VDD VSS IBIAS
CC NZ VOUT 2.2e-12
RZ V1 NZ 3800
XM1 D1 VINN TAIL VSS sky130_fd_pr__nfet_01v8 l=1 w=56 nf=1 m=1
XM2 V1 VINP TAIL VSS sky130_fd_pr__nfet_01v8 l=1 w=56 nf=1 m=1
XM3 D1 D1 VDD VDD sky130_fd_pr__pfet_01v8 l=1 w=83 nf=1 m=1
XM4 V1 D1 VDD VDD sky130_fd_pr__pfet_01v8 l=1 w=83 nf=1 m=1
XM5 TAIL IBIAS VSS VSS sky130_fd_pr__nfet_01v8 l=1 w=10 nf=1 m=5
XM6 VOUT V1 VDD VDD sky130_fd_pr__pfet_01v8 l=0.5 w=100 nf=1 m=2
XM7 VOUT IBIAS VSS VSS sky130_fd_pr__nfet_01v8 l=1 w=10 nf=1 m=15
XMB IBIAS IBIAS VSS VSS sky130_fd_pr__nfet_01v8 l=1 w=10 nf=1 m=1
.ends DUT
