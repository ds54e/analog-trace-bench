* LDO v9m: symmetric NMOS-input OTA, NMOS transconductor sinking from pass-gate mirror diode
.subckt DUT VIN VOUT VSS VREF
* bias reference current from VIN
RREF VIN nbn 200k
XMR nbn nbn VSS VSS sky130_fd_pr__nfet_01v8 W=100 L=1 nf=1 m=1
XM5 ntail nbn VSS VSS sky130_fd_pr__nfet_01v8 W=100 L=1 nf=1 m=4
* NMOS input pair
XM1 na VREF ntail VSS sky130_fd_pr__nfet_01v8 W=100 L=0.5 nf=1 m=16
XM2 nb FB ntail VSS sky130_fd_pr__nfet_01v8 W=100 L=0.5 nf=1 m=16
* PMOS diode loads and mirrors (M1 current sourced into nx, M2 current into n7)
* (source degeneration lowers the mirrors' noise contribution)
XMA na na nsa VIN sky130_fd_pr__pfet_01v8 W=100 L=0.5 nf=1 m=4
XMB nb nb nsb VIN sky130_fd_pr__pfet_01v8 W=100 L=0.5 nf=1 m=4
XMC nx na nsc VIN sky130_fd_pr__pfet_01v8 W=100 L=0.5 nf=1 m=4
XMD2 n7 nb nsd2 VIN sky130_fd_pr__pfet_01v8 W=100 L=0.5 nf=1 m=4
RSA VIN nsa 10k
RSB VIN nsb 10k
RSC VIN nsc 10k
RSD2 VIN nsd2 10k
* NMOS output mirror
XM7 n7 n7 VSS VSS sky130_fd_pr__nfet_01v8 W=100 L=8 nf=1 m=1
XM8 nx n7 VSS VSS sky130_fd_pr__nfet_01v8 W=100 L=8 nf=1 m=1
* gain network between output and mirror nodes (no DC current at balance):
* 500k mid-band, lag section adds low-frequency gain
RD1 nx nlag 500k
RD2 nlag n7 1.5meg
CD nlag n7 40p
* source-degenerated NMOS transconductor sinking from the pass-gate diode
XMD pg nx nsd VSS sky130_fd_pr__nfet_01v8 W=50 L=1 nf=1 m=1
RS nsd VSS 1.5k
* gate mirror diode and pass device (ratio 64)
XMM pg pg VIN VIN sky130_fd_pr__pfet_01v8 W=100 L=0.25 nf=1 m=1
XMPA VOUT pg VIN VIN sky130_fd_pr__pfet_01v8 W=100 L=0.25 nf=1 m=32
XMPB VOUT pg VIN VIN sky130_fd_pr__pfet_01v8 W=100 L=0.25 nf=1 m=32
* feedback divider
R1 VOUT FB 30k
* feed-forward capacitor: phase lead near the heavy-load crossover
CFF VOUT FB 15p
R2 FB VSS 30k
.ends DUT
