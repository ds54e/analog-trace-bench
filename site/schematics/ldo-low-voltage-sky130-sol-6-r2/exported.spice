.subckt DUT VIN VOUT VSS VREF
CDFIN VOUT DFSENSE 7p
CFB GATE VOUT 6p
CSHG UPDRIVE SHG 10p
CUFIN VOUT UPSENSE 7p
RBIAS VIN BIAS 30000
RDFIN DFBIAS DFSENSE 2000
RDFLOAD VIN FAST 200000
RDFREF VIN DFBIAS 200000
RFB FB VSS 50000
RFBIN FB GFB 500000
RFBVIN VIN GFB 2000000
RFT VOUT FB 49000
RREFIN VREF GREF 500000
RREFVIN VIN GREF 2000000
RSHG SHBIAS SHG 50000000
RSHREF VIN SHBIAS 500000
RUDRIVE UPDRIVE VSS 20000
RUFIN UPBIAS UPSENSE 50000
RUFLOAD UPNODE VSS 200000
RUFREF UPBIAS VSS 200000
XBIAS BIAS BIAS VSS VSS sky130_fd_pr__nfet_01v8 l=1 w=5 m=1
XDFG GATE FAST VSS VSS sky130_fd_pr__nfet_01v8 l=0.15 w=4 m=1
XDFREF DFBIAS DFBIAS VSS VSS sky130_fd_pr__nfet_01v8 l=0.15 w=100 m=1
XDFS FAST DFSENSE VSS VSS sky130_fd_pr__nfet_01v8 l=0.15 w=100 m=1
XINFB LEFT GFB TAIL VSS sky130_fd_pr__nfet_01v8 l=0.25 w=100 m=1
XINREF GATE GREF TAIL VSS sky130_fd_pr__nfet_01v8 l=0.25 w=100 m=1
XPASS VOUT GATE VIN VIN sky130_fd_pr__pfet_01v8 l=0.15 w=100 m=8
XPMIR1 LEFT LEFT VIN VIN sky130_fd_pr__pfet_01v8 l=0.5 w=20 m=1
XPMIR2 GATE LEFT VIN VIN sky130_fd_pr__pfet_01v8 l=0.5 w=20 m=1
XSHREF SHBIAS SHBIAS VSS VSS sky130_fd_pr__nfet_01v8 l=0.15 w=100 m=1
XSHUNT VOUT SHG VSS VSS sky130_fd_pr__nfet_01v8 l=0.15 w=100 m=1
XTAIL TAIL BIAS VSS VSS sky130_fd_pr__nfet_01v8 l=1 w=5 m=1
XUFG UPDRIVE UPNODE VIN VIN sky130_fd_pr__pfet_01v8 l=0.15 w=100 m=1
XUFREF UPBIAS UPBIAS VIN VIN sky130_fd_pr__pfet_01v8 l=0.15 w=100 m=1
XUFS UPNODE UPSENSE VIN VIN sky130_fd_pr__pfet_01v8 l=0.15 w=100 m=1
.ends DUT
