* Continuous-time 1 V LDO
.subckt DUT VIN VOUT VSS VREF
* PMOS pass transistor
XPASS VOUT GATE VIN VIN sky130_fd_pr__pfet_01v8 w=100 l=0.15 m=8
CFB GATE VOUT 6p
* Feedback divider
RFT VOUT FB 49000
RFB FB VSS 50000
* Bias reference and NMOS differential tail
RBIAS VIN BIAS 30000
XBIAS BIAS BIAS VSS VSS sky130_fd_pr__nfet_01v8 w=5 l=1 m=1
XTAIL TAIL BIAS VSS VSS sky130_fd_pr__nfet_01v8 w=5 l=1 m=1
* Error amplifier: rising feedback raises the pass gate
RFBIN FB GFB 500000
RFBVIN VIN GFB 2000000
RREFIN VREF GREF 500000
RREFVIN VIN GREF 2000000
XINFB LEFT GFB TAIL VSS sky130_fd_pr__nfet_01v8 w=100 l=0.25 m=1
XINREF GATE GREF TAIL VSS sky130_fd_pr__nfet_01v8 w=100 l=0.25 m=1
XPMIR1 LEFT LEFT VIN VIN sky130_fd_pr__pfet_01v8 w=20 l=0.5 m=1
XPMIR2 GATE LEFT VIN VIN sky130_fd_pr__pfet_01v8 w=20 l=0.5 m=1
* Self-biased AC fast discharge
RDFREF VIN DFBIAS 200000
XDFREF DFBIAS DFBIAS VSS VSS sky130_fd_pr__nfet_01v8 w=100 l=0.15 m=1
RDFIN DFBIAS DFSENSE 2000
CDFIN VOUT DFSENSE 7p
RDFLOAD VIN FAST 200000
XDFS FAST DFSENSE VSS VSS sky130_fd_pr__nfet_01v8 w=100 l=0.15 m=1
XDFG GATE FAST VSS VSS sky130_fd_pr__nfet_01v8 w=4 l=0.15 m=1
* Matched AC fast charge for a rising output
RUFREF UPBIAS VSS 200000
XUFREF UPBIAS UPBIAS VIN VIN sky130_fd_pr__pfet_01v8 w=100 l=0.15 m=1
RUFIN UPBIAS UPSENSE 50000
CUFIN VOUT UPSENSE 7p
RUFLOAD UPNODE VSS 200000
XUFS UPNODE UPSENSE VIN VIN sky130_fd_pr__pfet_01v8 w=100 l=0.15 m=1
XUFG UPDRIVE UPNODE VIN VIN sky130_fd_pr__pfet_01v8 w=100 l=0.15 m=1
RUDRIVE UPDRIVE VSS 20000
RSHREF VIN SHBIAS 500000
XSHREF SHBIAS SHBIAS VSS VSS sky130_fd_pr__nfet_01v8 w=100 l=0.15 m=1
RSHG SHBIAS SHG 50000000
CSHG UPDRIVE SHG 10p
XSHUNT VOUT SHG VSS VSS sky130_fd_pr__nfet_01v8 w=100 l=0.15 m=1
.ends DUT
