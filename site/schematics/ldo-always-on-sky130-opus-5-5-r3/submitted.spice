* always-on LDO: 5T OTA (gain-limited by RLIM) -> PMOS CS -> NMOS mirror -> PMOS diode/pass mirror
.subckt DUT VIN VOUT VSS VREF
RB VIN NB 9000000.0
XMB NB NB VSS VSS sky130_fd_pr__nfet_01v8 W=4 L=1 nf=1 m=1
XMT NT NB VSS VSS sky130_fd_pr__nfet_01v8 W=4 L=1 nf=1 m=8
XM1 N3 FB NT VSS sky130_fd_pr__nfet_01v8 W=50 L=0.5 nf=1 m=4
XM2 N1 VREF NT VSS sky130_fd_pr__nfet_01v8 W=50 L=0.5 nf=1 m=4
XM3 N3 N3 VIN VIN sky130_fd_pr__pfet_01v8 W=8 L=1 nf=1 m=1
XM4 N1 N3 VIN VIN sky130_fd_pr__pfet_01v8 W=8 L=1 nf=1 m=1
RLIM N1 N3 30000000.0
XM5 N6 N1 VIN VIN sky130_fd_pr__pfet_01v8 W=0.8 L=1 nf=1 m=1
XM6 N6 N6 VSS VSS sky130_fd_pr__nfet_01v8 W=4 L=1 nf=1 m=1
XM7 NG N6 VSS VSS sky130_fd_pr__nfet_01v8 W=4 L=1 nf=1 m=5
XMD NG NG VIN VIN sky130_fd_pr__pfet_01v8 W=5 L=0.5 nf=1 m=1
XMP VOUT NG VIN VIN sky130_fd_pr__pfet_01v8 W=100 L=0.5 nf=1 m=2
RTOP VOUT FB 4000000.0
RBOT FB VSS 4000000.0
CFF VOUT FB 1.5e-13
.ends DUT
