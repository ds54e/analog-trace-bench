.subckt DUT VIN VOUT VSS VREF
CAMP AMP VSS 1p
CFEED VOUT NR 0.5p
CINPUT VOUT FB 1p
RFB FB VSS 17.647k
RFT VOUT FB 100k
RLOCAL VOUT GATE 22k
RPU VIN GATE 20k
RRB REFG VSS 3meg
RRT VREF REFG 7meg
RTAIL VIN TAIL 11k
XNDRIVE GATE AMP VSS VSS sky130_fd_pr__nfet_01v8 l=0.15 w=100 m=1
XNFB AMP NR VSS VSS sky130_fd_pr__nfet_01v8 l=1 w=10 m=1
XNREF NR NR VSS VSS sky130_fd_pr__nfet_01v8 l=1 w=10 m=1
XPFB AMP FB TAIL VIN sky130_fd_pr__pfet_01v8 l=0.5 w=100 m=8
XPPASS VOUT GATE VIN VIN sky130_fd_pr__pfet_01v8 l=0.15 w=100 m=3
XPREF NR REFG TAIL VIN sky130_fd_pr__pfet_01v8 l=0.5 w=100 m=8
.ends DUT
