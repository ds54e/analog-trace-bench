* Two-stage Miller OTA v4: ratio-matched PMOS mirror/output stage
.subckt DUT VINP VINN VOUT VDD VSS IBIAS
* bias reference (IREF flows into IBIAS)
XMB IBIAS IBIAS VSS VSS sky130_fd_pr__nfet_01v8 W=4 L=1 nf=1 m=1
* tail current source (8x -> 80uA)
XM5 NT IBIAS VSS VSS sky130_fd_pr__nfet_01v8 W=4 L=1 nf=1 m=8
* input pair, M1 gate = inverting input, M2 gate = non-inverting input
XM1 N1 VINN S1 VSS sky130_fd_pr__nfet_01v8 W=25 L=0.5 nf=1 m=4
XM2 O1 VINP S2 VSS sky130_fd_pr__nfet_01v8 W=25 L=0.5 nf=1 m=4
RS1 S1 NT 1500
RS2 S2 NT 1500
* PMOS mirror load
XM3 N1 N1 VDD VDD sky130_fd_pr__pfet_01v8 W=70 L=0.5 nf=1 m=1
XM4 O1 N1 VDD VDD sky130_fd_pr__pfet_01v8 W=70 L=0.5 nf=1 m=1
* second stage: M6 = 4x M3 (density matched), M7 sinks 160uA
XM6 VOUT O1 VDD VDD sky130_fd_pr__pfet_01v8 W=70 L=0.5 nf=1 m=4
XM7 VOUT IBIAS VSS VSS sky130_fd_pr__nfet_01v8 W=4 L=1 nf=1 m=16
* compensation
CC O1 NZ 2.2p
RZ NZ VOUT 1900
.ends DUT
