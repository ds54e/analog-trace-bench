* Rail-to-rail input two-stage OTA: complementary pairs, folded-cascode summing
* with resistor-degenerated current sources (low noise), NMOS common-source output
* with VDD-referenced PMOS load, Miller compensation with nulling resistor.
* Low-density (weak-inversion) tails/pairs for headroom at VDD=1.35V, cold, slow.
.subckt DUT VINP VINN VOUT VDD VSS IBIAS
* ---- bias network (IREF = 10uA into IBIAS) ----
XMB0 IBIAS IBIAS VSS VSS sky130_fd_pr__nfet_01v8 W=10 L=0.5 nf=1 m=4
* VBP diode (10uA): output load, NMOS-cascode-bias feeder
XMS1 VBP IBIAS VSS VSS sky130_fd_pr__nfet_01v8 W=10 L=0.5 nf=1 m=4
XMPB1 VBP VBP VDD VDD sky130_fd_pr__pfet_01v8 W=10 L=0.5 nf=1 m=2
* VBT diode (10uA, low density): PMOS tail
XMS4 VBT IBIAS VSS VSS sky130_fd_pr__nfet_01v8 W=10 L=0.5 nf=1 m=4
XMPB3 VBT VBT VDD VDD sky130_fd_pr__pfet_01v8 W=20 L=0.5 nf=1 m=4
* VBP2 degenerated diode (10uA, 0.15V on resistor): folded-cascode top sources
XMS3 VBP2 IBIAS VSS VSS sky130_fd_pr__nfet_01v8 W=10 L=0.5 nf=1 m=4
RB2 VDD PB2 15k
XMPB2 VBP2 VBP2 PB2 VDD sky130_fd_pr__pfet_01v8 W=10 L=0.5 nf=1 m=2
* PMOS cascode bias: VDD - R*5uA - Vsg
RPC VDD PR 56k
XMPBC PBC PBC PR VDD sky130_fd_pr__pfet_01v8 W=10 L=0.5 nf=1 m=1
XMS2 PBC IBIAS VSS VSS sky130_fd_pr__nfet_01v8 W=10 L=0.5 nf=1 m=2
* NMOS cascode bias: R*5uA + Vgs
XMPX NBC VBP VDD VDD sky130_fd_pr__pfet_01v8 W=10 L=0.5 nf=1 m=1
XMNBC NBC NBC NR VSS sky130_fd_pr__nfet_01v8 W=5 L=0.5 nf=1 m=1
RNC NR VSS 48k
* ---- input stage ----
* NMOS pair (VINP on output side), 30uA tail
XMNT TN IBIAS VSS VSS sky130_fd_pr__nfet_01v8 W=10 L=0.5 nf=1 m=12
XM1 A1 VINN TN VSS sky130_fd_pr__nfet_01v8 W=20 L=1 nf=1 m=16
XM2 A2 VINP TN VSS sky130_fd_pr__nfet_01v8 W=20 L=1 nf=1 m=16
* PMOS pair, 30uA tail
XMPT TP VBT VDD VDD sky130_fd_pr__pfet_01v8 W=20 L=0.5 nf=1 m=12
XM3 C1 VINN TP VDD sky130_fd_pr__pfet_01v8 W=15 L=0.5 nf=1 m=32
XM4 C2 VINP TP VDD sky130_fd_pr__pfet_01v8 W=15 L=0.5 nf=1 m=32
* ---- folded cascode summing (40uA top sources) ----
RS5 VDD S5 3.75k
RS6 VDD S6 3.75k
XMP5 A1 VBP2 S5 VDD sky130_fd_pr__pfet_01v8 W=10 L=0.5 nf=1 m=8
XMP6 A2 VBP2 S6 VDD sky130_fd_pr__pfet_01v8 W=10 L=0.5 nf=1 m=8
XMP7 B1 PBC A1 VDD sky130_fd_pr__pfet_01v8 W=10 L=0.5 nf=1 m=5
XMP8 O1 PBC A2 VDD sky130_fd_pr__pfet_01v8 W=10 L=0.5 nf=1 m=5
XMN7 B1 NBC C1 VSS sky130_fd_pr__nfet_01v8 W=5 L=0.5 nf=1 m=8
XMN8 O1 NBC C2 VSS sky130_fd_pr__nfet_01v8 W=5 L=0.5 nf=1 m=8
XMN5 C1 B1 D5 VSS sky130_fd_pr__nfet_01v8 W=5 L=0.5 nf=1 m=10
XMN6 C2 B1 D6 VSS sky130_fd_pr__nfet_01v8 W=5 L=0.5 nf=1 m=10
RD5 D5 VSS 2.5k
RD6 D6 VSS 2.5k
* ---- output stage (100uA) ----
XMNO VOUT O1 VSS VSS sky130_fd_pr__nfet_01v8 W=10 L=0.5 nf=1 m=12
XMPL VOUT VBP VDD VDD sky130_fd_pr__pfet_01v8 W=10 L=0.5 nf=1 m=20
* ---- compensation ----
RZ O1 OZ 1.5k
CC OZ VOUT 6p
.ends DUT
