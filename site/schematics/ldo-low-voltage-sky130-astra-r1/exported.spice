.subckt DUT VIN VOUT VSS VREF
CCOMP CM VOUT 3p
CFF VOUT FB 10p
CREF VR VSS 5p
RBIAS VIN NB 120k
RCOMP PG CM 5k
RFBG FB VSS {55000/(0.425-0.275*0.008)}
RFBO VOUT FB {200000/1.008}
RFBV VIN FB {550000/3}
RREFG VR VSS 1.1meg
RREFR VREF VR 300k
RREFV VIN VR 550k
XIN1 N1 FB TAIL VSS sky130_fd_pr__nfet_01v8 l=0.5 w=100 nf=1 m=4
XIN2 PG VR TAIL VSS sky130_fd_pr__nfet_01v8 l=0.5 w=100 nf=1 m=4
XNB NB NB VSS VSS sky130_fd_pr__nfet_01v8 l=2 w=20 nf=1 m=1
XPASS VOUT PG VIN VIN sky130_fd_pr__pfet_01v8 l=0.15 w=100 nf=1 m=4
XPM1 N1 N1 VIN VIN sky130_fd_pr__pfet_01v8 l=0.5 w=100 nf=1 m=4
XPM2 PG N1 VIN VIN sky130_fd_pr__pfet_01v8 l=0.5 w=100 nf=1 m=4
XTAIL TAIL NB VSS VSS sky130_fd_pr__nfet_01v8 l=2 w=100 nf=1 m=2
.ends DUT
