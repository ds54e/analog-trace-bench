* auto
.subckt DUT VIN VOUT VSS VREF
R1 VOUT VFB 296.5k
R2 VFB VSS 300k
C1 VOUT VFB 5p
C2 VFB VSS 0.1p
RB VIN NB 460k
XMB NB NB VSS VSS sky130_fd_pr__nfet_01v8 W=5 L=1 nf=1 m=1
XMT TAIL NB VSS VSS sky130_fd_pr__nfet_01v8 W=5 L=1 nf=1 m=8
XM1 D1 VFB TAIL VSS sky130_fd_pr__nfet_01v8 W=60 L=0.4 nf=1 m=2
XM2 X VREF TAIL VSS sky130_fd_pr__nfet_01v8 W=60 L=0.4 nf=1 m=2
XM3 D1 D1 VIN VIN sky130_fd_pr__pfet_01v8 W=4 L=0.5 nf=1 m=2
XM4 X D1 VIN VIN sky130_fd_pr__pfet_01v8 W=4 L=0.5 nf=1 m=2
XMP VOUT X VIN VIN sky130_fd_pr__pfet_01v8 W=100 L=0.15 nf=1 m=2
RZ X NZ 160k
CC NZ VIN 2.5p
CM VOUT X 0.05p

.ends DUT
