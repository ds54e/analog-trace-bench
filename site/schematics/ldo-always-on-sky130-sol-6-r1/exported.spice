.subckt DUT VIN VOUT VSS VREF
CCOMP GATE VOUT 0.1p
CFF VOUT FB 5p
RBIAS BIAS VSS 900k
RBOT FB VSS 4meg
RTOP VOUT FB 4meg
XBIAS BIAS BIAS VIN VIN sky130_fd_pr__pfet_01v8 l=2 w=2
XINFB NDIOD FB TAIL VIN sky130_fd_pr__pfet_01v8 l=0.5 w=40
XINREF GATE VREF TAIL VIN sky130_fd_pr__pfet_01v8 l=0.5 w=40
XNLOAD NDIOD NDIOD VSS VSS sky130_fd_pr__nfet_01v8 l=2 w=2
XNMIR GATE NDIOD VSS VSS sky130_fd_pr__nfet_01v8 l=2 w=2
XPASS VOUT GATE VIN VIN sky130_fd_pr__pfet_01v8 l=0.5 w=100 m=2
XTAIL TAIL BIAS VIN VIN sky130_fd_pr__pfet_01v8 l=2 w=2
.ends DUT
