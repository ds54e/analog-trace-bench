.subckt DUT VIN VOUT VSS VREF
CC GA VOUT 30p
RB NB VSS 200k
RFA VOUT FB 600k
RFB FB VSS 200k
RL VOUT VSS 20k
RVA VREF VR 1meg
RVB VR VSS 1meg
XM1 D1 FB VIN VIN sky130_fd_pr__pfet_01v8 l=0.5 w=20 nf=1 m=1
XM2 GA VR VIN VIN sky130_fd_pr__pfet_01v8 l=0.5 w=20 nf=1 m=1
XM3 D1 D1 VSS VSS sky130_fd_pr__nfet_01v8 l=0.5 w=20 nf=1 m=1
XM4 GA D1 VSS VSS sky130_fd_pr__nfet_01v8 l=0.5 w=20 nf=1 m=1
XM5 S1 NB VIN VIN sky130_fd_pr__pfet_01v8 l=0.5 w=20 nf=1 m=8
XM6 NB NB VIN VIN sky130_fd_pr__pfet_01v8 l=0.5 w=20 nf=1 m=1
XMP0 VOUT GA VIN VIN sky130_fd_pr__pfet_01v8 l=0.15 w=100 nf=1 m=32
.ends DUT
