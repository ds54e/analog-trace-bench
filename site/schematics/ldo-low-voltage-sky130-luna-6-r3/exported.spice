.subckt DUT VIN VOUT VSS VREF
CCOMP COMP VG 0.52p
CFF VOUT VFB 29.48p
RFB1 VOUT VFB 49.8k
RFB2 VFB VSS 47.5k
RFF VFF VFB 600k
RFFLINE VFFLINE VFB 400k
RFG1 VIN VFFG 8meg
RFG2 VFFG VREF 2meg
RGPULL VIN VG 12k
RPBIAS PBIAS VSS 180k
RZ X COMP 17.5k
XMNDRIVE VG X VSS VSS sky130_fd_pr__nfet_01v8 l=0.15 w=18.8
XMNLOAD1 NL NL VSS VSS sky130_fd_pr__nfet_01v8 l=0.5 w=10
XMNLOAD2 X NL VSS VSS sky130_fd_pr__nfet_01v8 l=0.5 w=10
XMPASS VOUT VG VIN VIN sky130_fd_pr__pfet_01v8 l=0.15 w=100 m=32
XMPFBIN X VFB PS VIN sky130_fd_pr__pfet_01v8 l=0.15 w=100 m=8
XMPFF VFF VREF VOUT VIN sky130_fd_pr__pfet_01v8 l=0.15 w=100
XMPFFLINE VFFLINE VFFG VIN VIN sky130_fd_pr__pfet_01v8 l=1 w=100 m=2
XMPREF PBIAS PBIAS VIN VIN sky130_fd_pr__pfet_01v8 l=0.5 w=10
XMPREFIN NL VREF PS VIN sky130_fd_pr__pfet_01v8 l=0.15 w=100 m=8
XMPTAIL PS PBIAS VIN VIN sky130_fd_pr__pfet_01v8 l=0.5 w=100 m=2
.ends DUT
