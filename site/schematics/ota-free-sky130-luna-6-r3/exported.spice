.subckt DUT VINP VINN VOUT VDD VSS IBIAS
CC NC VOUT 1.55p
RBIAS N2 VSS 300000
RZ N2 NC 4k
XINN N1 VINN NT VSS sky130_fd_pr__nfet_01v8 l=0.8 w=30
XINP N2 VINP NT VSS sky130_fd_pr__nfet_01v8 l=0.8 w=30
XLOADD N1 N1 VDD VDD sky130_fd_pr__pfet_01v8 l=1.5 w=60
XLOADM N2 N1 VDD VDD sky130_fd_pr__pfet_01v8 l=1.5 w=80
XNBIAS VBP IBIAS VSS VSS sky130_fd_pr__nfet_01v8 l=0.8 w=100
XNR IBIAS IBIAS VSS VSS sky130_fd_pr__nfet_01v8 l=0.8 w=100
XOUTN VOUT N2 VSS VSS sky130_fd_pr__nfet_01v8 l=1.5 w=100
XOUTP VOUT VBP VDD VDD sky130_fd_pr__pfet_01v8 l=1.5 w=100 m=8
XPBIAS VBP VBP VDD VDD sky130_fd_pr__pfet_01v8 l=1.5 w=30
XTAIL NT IBIAS VSS VSS sky130_fd_pr__nfet_01v8 l=0.8 w=100 m=2
.ends DUT
