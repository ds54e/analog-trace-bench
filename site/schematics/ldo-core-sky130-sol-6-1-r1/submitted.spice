* Current-mirror error amplifier driving a PMOS pass device
.subckt DUT VIN VOUT VSS VREF
RFB1 VOUT FB 353k
RFB2 FB VSS 120k
RBIAS VIN BN 700k
XNB BN BN VSS VSS sky130_fd_pr__nfet_01v8 w=2 l=2 nf=1 m=1
XNBP BP BN VSS VSS sky130_fd_pr__nfet_01v8 w=2 l=2 nf=1 m=1
XBP BP BP VIN VIN sky130_fd_pr__pfet_01v8 w=2 l=2 nf=1 m=8
XTAIL ST BP VIN VIN sky130_fd_pr__pfet_01v8 w=2 l=2 nf=1 m=32
* Reduced common-mode PMOS differential inputs
XIN1 NR VR ST VIN sky130_fd_pr__pfet_01v8 w=40 l=0.5 nf=1 m=1
XIN2 NF FB ST VIN sky130_fd_pr__pfet_01v8 w=40 l=0.5 nf=1 m=1
XNR NR NR VSS VSS sky130_fd_pr__nfet_01v8 w=4 l=0.5 nf=1 m=1
XNF NF NF VSS VSS sky130_fd_pr__nfet_01v8 w=4 l=0.5 nf=1 m=1
* Current gain of five, with balanced pullup and pulldown
XNX UP NR VSS VSS sky130_fd_pr__nfet_01v8 w=4 l=0.5 nf=1 m=1
XPU UP UP VIN VIN sky130_fd_pr__pfet_01v8 w=4 l=0.5 nf=1 m=4
XPDRV GP UP VIN VIN sky130_fd_pr__pfet_01v8 w=4 l=0.5 nf=1 m=20
XNDRV GP NF VSS VSS sky130_fd_pr__nfet_01v8 w=4 l=0.5 nf=1 m=5
XPASS VOUT GP VIN VIN sky130_fd_pr__pfet_01v8 w=100 l=0.15 nf=1 m=4
RCOMP GP CZ 8k
CCOMP CZ VOUT 4p
CFF VOUT FB 3p
* Load-dependent bias boost, sensed from the pass gate
XSENSE BA GP VIN VIN sky130_fd_pr__pfet_01v8 w=0.6 l=0.15 nf=1 m=1
XAD BA BA VSS VSS sky130_fd_pr__nfet_01v8 w=2 l=2 nf=1 m=4
XADB BP BA VSS VSS sky130_fd_pr__nfet_01v8 w=2 l=2 nf=1 m=1
* AC-coupled active discharge for falling load edges
RDIS GD BN 500k
CDIS GP GD 2p
XDIS VOUT GD VSS VSS sky130_fd_pr__nfet_01v8 w=2 l=2 nf=1 m=4
RVR1 VREF VR 310k
RVR2 VR VSS 310k
CVR VR VSS 4p
* Transient bias boost
CBOOST GP BP 0.15p
.ends DUT
