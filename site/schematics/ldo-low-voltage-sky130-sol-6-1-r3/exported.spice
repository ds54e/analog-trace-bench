.subckt DUT VIN VOUT VSS VREF
CFBH VIN IFB 2.4p
CFBLO IFB VSS 2p
CFBOUT VOUT IFB 3.6p
CLOCAL GP IR 0.4p
CREFH VIN IR 2.4p
CREFL VREF IR 5.6p
RB VIN NB 85k
RBLEED VOUT VSS 50k
RFBH VIN IFB 700k
RFBLO IFB VSS 600k
RFBOUT VOUT IFB 600k
RREFH VIN IR 700k
RREFL VREF IR 300k
XAB NA NA VSS VSS sky130_fd_pr__nfet_01v8 l=1 w=10 nf=1 m=1
XBOOST NS NA VSS VSS sky130_fd_pr__nfet_01v8 l=1 w=30 nf=1 m=1
XFB ND IFB NS VSS sky130_fd_pr__nfet_01v8 l=0.5 w=100 nf=1 m=1
XNB NB NB VSS VSS sky130_fd_pr__nfet_01v8 l=1 w=10 nf=1 m=1
XPASS VOUT GP VIN VIN sky130_fd_pr__pfet_01v8 l=0.15 w=100 nf=1 m=4
XPL ND ND VIN VIN sky130_fd_pr__pfet_01v8 l=0.25 w=100 nf=1 m=4
XPR GP ND VIN VIN sky130_fd_pr__pfet_01v8 l=0.25 w=100 nf=1 m=4
XREF GP IR NS VSS sky130_fd_pr__nfet_01v8 l=0.5 w=100 nf=1 m=1
XSENSE NA GP VIN VIN sky130_fd_pr__pfet_01v8 l=0.15 w=3 nf=1 m=1
XTAIL NS NB VSS VSS sky130_fd_pr__nfet_01v8 l=1 w=50 nf=1 m=1
.ends DUT
