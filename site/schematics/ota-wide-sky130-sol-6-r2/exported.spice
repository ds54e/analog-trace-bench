.subckt DUT VINP VINN VOUT VDD VSS IBIAS
CBN SHN VSS 0.45p
CBP SHP VSS 0.45p
CC CZ VOUT 7p
CTN VINN SHN 0.3p
CTP VINP SHP 0.3p
RAL VDD NDL 80k
RAR VDD NDR 80k
RBN SHN VSS 300k
RBP SHP VSS 300k
RG GATE PBIAS 100k
RPSL VDD SPL 900
RPSR VDD SPR 900
RSENSE NSENSE VSS 20k
RTAILP VDD PTAIL 3.25k
RTN VINN SHN 900k
RTP VINP SHP 900k
RZ GATE CZ 2.5k
XNB PBIAS IBIAS VSS VSS sky130_fd_pr__nfet_01v8 l=2 w=10 m=1
XNFD FDL FDL VSS VSS sky130_fd_pr__nfet_01v8 l=3 w=40 m=1
XNFO GATE FDL VSS VSS sky130_fd_pr__nfet_01v8 l=3 w=40 m=1
XNIL NDL VINN NTAIL VSS sky130_fd_pr__nfet_01v8 l=0.5 w=100 m=2
XNIR NDR VINP NTAIL VSS sky130_fd_pr__nfet_01v8 l=0.5 w=100 m=2
XNPD PDL PDL VSS VSS sky130_fd_pr__nfet_01v8 l=5 w=35 m=1
XNPO GATE PDL VSS VSS sky130_fd_pr__nfet_01v8 l=5 w=35 m=1
XNR IBIAS IBIAS VSS VSS sky130_fd_pr__nfet_01v8 l=2 w=10 m=1
XNSN PSENSE VINN NSENSE VSS sky130_fd_pr__nfet_01v8 l=0.5 w=100 m=1
XNSP PSENSE VINP NSENSE VSS sky130_fd_pr__nfet_01v8 l=0.5 w=100 m=1
XNT NTAIL IBIAS VSS VSS sky130_fd_pr__nfet_01v8 l=2 w=40 m=1
XONS VOUT IBIAS VSS VSS sky130_fd_pr__nfet_01v8 l=2 w=67.5 m=1
XOP VOUT GATE VDD VDD sky130_fd_pr__pfet_01v8 l=1 w=85 m=4
XPFL FDL VSS NDL VDD sky130_fd_pr__pfet_01v8 l=1 w=50 m=1
XPFR GATE VSS NDR VDD sky130_fd_pr__pfet_01v8 l=1 w=50 m=1
XPIL PDL SHN PTAIL VDD sky130_fd_pr__pfet_01v8 l=1 w=100 m=1
XPIR GATE SHP PTAIL VDD sky130_fd_pr__pfet_01v8 l=1 w=100 m=1
XPR PBIAS PBIAS VDD VDD sky130_fd_pr__pfet_01v8 l=2 w=20 m=1
XPSL NDL PSENSE SPL VDD sky130_fd_pr__pfet_01v8 l=2 w=100 m=1
XPSR NDR PSENSE SPR VDD sky130_fd_pr__pfet_01v8 l=2 w=100 m=1
XPSREF PSENSE PSENSE VDD VDD sky130_fd_pr__pfet_01v8 l=2 w=20 m=1
.ends DUT
