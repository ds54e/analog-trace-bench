* LDO v10
.subckt DUT VIN VOUT VSS VREF
R1 VOUT FB 20k
R2 FB VSS 19.36k
R3 VIN FB 900k
CFF VOUT FB 7p
RB VIN VB 160k
XMB VB VB VSS VSS sky130_fd_pr__nfet_01v8 W=50 L=1 nf=1 m=4
XMT T VB VSS VSS sky130_fd_pr__nfet_01v8 W=50 L=1 nf=1 m=16
XM1 A VREF T VSS sky130_fd_pr__nfet_01v8 W=100 L=1 nf=1 m=12
XM2 H FB T VSS sky130_fd_pr__nfet_01v8 W=100 L=1 nf=1 m=12
XMA A A VIN VIN sky130_fd_pr__pfet_01v8 W=100 L=2 nf=1 m=4
XMG H A VIN VIN sky130_fd_pr__pfet_01v8 W=100 L=2 nf=1 m=4
XMH H H VSS VSS sky130_fd_pr__nfet_01v8 W=5.4 L=0.3 nf=1 m=1
XMK G H VSS VSS sky130_fd_pr__nfet_01v8 W=94.5 L=0.3 nf=1 m=6
XMD G G VIN VIN sky130_fd_pr__pfet_01v8 W=80 L=0.4 nf=1 m=1
XMP VOUT G VIN VIN sky130_fd_pr__pfet_01v8 W=100 L=0.4 nf=1 m=32
.ends DUT
