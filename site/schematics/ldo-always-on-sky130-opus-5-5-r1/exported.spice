.subckt DUT VIN VOUT VSS VREF
CFF VOUT FB 1p
R1 VOUT FB 3meg
R2 FB VSS 3meg
RB PB VSS 10meg
XM1 A VREF T VIN sky130_fd_pr__pfet_01v8 l=0.5 w=10 nf=1 m=4
XM2 X FB T VIN sky130_fd_pr__pfet_01v8 l=0.5 w=10 nf=1 m=4
XM3 A A VSS VSS sky130_fd_pr__nfet_01v8 l=1 w=3 nf=1 m=1
XM4 X A VSS VSS sky130_fd_pr__nfet_01v8 l=1 w=3 nf=1 m=1
XM5 T PB VIN VIN sky130_fd_pr__pfet_01v8 l=2 w=2 nf=1 m=4
XMB G X VSS VSS sky130_fd_pr__nfet_01v8 l=1 w=3 nf=1 m=1
XMD G G VIN VIN sky130_fd_pr__pfet_01v8 l=0.35 w=7 nf=1 m=1
XMP VOUT G VIN VIN sky130_fd_pr__pfet_01v8 l=0.35 w=87.5 nf=1 m=4
XMPB PB PB VIN VIN sky130_fd_pr__pfet_01v8 l=2 w=2 nf=1 m=1
XMS T G VIN VIN sky130_fd_pr__pfet_01v8 l=0.35 w=7 nf=1 m=1
.ends DUT
