* LDO v5: folded-cascode NMOS-input EA with VIN-referenced matched level shift, PI comp, mirror-driven PMOS pass
.subckt DUT VIN VOUT VSS VREF
XMP VOUT VG VIN VIN sky130_fd_pr__pfet_01v8 W=100 L=0.15 m=20
XMD E VG VIN VIN sky130_fd_pr__pfet_01v8 W=80 L=0.15 m=1
RE E VG 4k
XM2 VG X VSS VSS sky130_fd_pr__nfet_01v8 W=20 L=0.15 m=1
RZ X XZ 30k
CZ XZ VSS 15p
RA VOUT FB 16.74k
RB FB VSS 16.5k
RT1 VIN RU 780k
RB1 RU VREF 420k
CR RU VSS 1p
RT2 VIN FU 780k
RB2 FU FB 420k
CAC VOUT FU 3p
XN1 F1 RU T VSS sky130_fd_pr__nfet_01v8 W=80 L=1 m=1
XN2 F2 FU T VSS sky130_fd_pr__nfet_01v8 W=80 L=1 m=1
XNT T NB VSS VSS sky130_fd_pr__nfet_01v8 W=40 L=1 m=1
XPS1 F1 VBP VIN VIN sky130_fd_pr__pfet_01v8 W=40 L=0.15 m=1
XPS2 F2 VBP VIN VIN sky130_fd_pr__pfet_01v8 W=40 L=0.15 m=1
XPC1 O1 VBC F1 VIN sky130_fd_pr__pfet_01v8 W=40 L=0.15 m=1
XPC2 X VBC F2 VIN sky130_fd_pr__pfet_01v8 W=40 L=0.15 m=1
XNM1 O1 O1 VSS VSS sky130_fd_pr__nfet_01v8 W=20 L=1 m=1
XNM2 X O1 VSS VSS sky130_fd_pr__nfet_01v8 W=20 L=1 m=1
XPB Q1 VBP VIN VIN sky130_fd_pr__pfet_01v8 W=10 L=0.15 m=1
XPBC VBP VBC Q1 VIN sky130_fd_pr__pfet_01v8 W=10 L=0.15 m=1
RCB VBP VBC 30k
XNPB VBC NB VSS VSS sky130_fd_pr__nfet_01v8 W=8 L=1 m=1
XNB NB NB VSS VSS sky130_fd_pr__nfet_01v8 W=5 L=1 m=1
RBIAS VIN NB 300k

.ends DUT
