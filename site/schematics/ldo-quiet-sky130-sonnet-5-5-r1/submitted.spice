* LDO generated
.subckt DUT VIN VOUT VSS VREF
XMP VOUT VG VIN VIN sky130_fd_pr__pfet_01v8 W=100 L=0.25 nf=1 m=25
R1 VOUT FB 22070.0
R2 FB VSS 22200.0
XM1 N1 FB TL VSS sky130_fd_pr__nfet_01v8 W=100 L=1 nf=1 m=8
XM2 VG VREF TL VSS sky130_fd_pr__nfet_01v8 W=100 L=1 nf=1 m=8
XM3 N1 N1 VIN VIN sky130_fd_pr__pfet_01v8 W=10 L=0.5 nf=1 m=8
XM4 VG N1 VIN VIN sky130_fd_pr__pfet_01v8 W=10 L=0.5 nf=1 m=8
XM5 TL BN VSS VSS sky130_fd_pr__nfet_01v8 W=100 L=0.5 nf=1 m=1
RB VIN BN 190000.0
XMB BN BN VSS VSS sky130_fd_pr__nfet_01v8 W=12.5 L=0.5 nf=1 m=1
RZ VG VZ 50000.0
CC VZ VIN 6e-11
.ends DUT
