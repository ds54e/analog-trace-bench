.subckt DUT VINP VINN VOUT VDD VSS IBIAS
CBIAS IBIAS VSS 1p
CCOMP NC VOUT 15p
RCOMP N1 NC 500
XINN ND VINN NT VSS sky130_fd_pr__nfet_01v8 l=1 w=100 nf=1 m=3
XINP N1 VINP NT VSS sky130_fd_pr__nfet_01v8 l=1 w=100 nf=1 m=3
XOUTN VOUT IBIAS VSS VSS sky130_fd_pr__nfet_01v8 l=1 w=100 nf=1 m=4
XOUTP VOUT N1 VDD VDD sky130_fd_pr__pfet_01v8 l=0.5 w=100 nf=1 m=20
XPD ND ND VDD VDD sky130_fd_pr__pfet_01v8 l=0.5 w=100 nf=1 m=4
XPM N1 ND VDD VDD sky130_fd_pr__pfet_01v8 l=0.5 w=100 nf=1 m=4
XREF IBIAS IBIAS VSS VSS sky130_fd_pr__nfet_01v8 l=1 w=4 nf=1 m=1
XTAIL NT IBIAS VSS VSS sky130_fd_pr__nfet_01v8 l=1 w=100 nf=1 m=1
.ends DUT
