* Two-stage continuous-time OTA with Miller compensation.
.subckt DUT VINP VINN VOUT VDD VSS IBIAS
XREF IBIAS IBIAS VSS VSS sky130_fd_pr__nfet_01v8 w=4 l=1 nf=1 m=1
XTAIL NT IBIAS VSS VSS sky130_fd_pr__nfet_01v8 w=100 l=1 nf=1 m=1
XINP N1 VINP NT VSS sky130_fd_pr__nfet_01v8 w=100 l=1 nf=1 m=3
XINN ND VINN NT VSS sky130_fd_pr__nfet_01v8 w=100 l=1 nf=1 m=3
XPD ND ND VDD VDD sky130_fd_pr__pfet_01v8 w=100 l=0.5 nf=1 m=4
XPM N1 ND VDD VDD sky130_fd_pr__pfet_01v8 w=100 l=0.5 nf=1 m=4
XOUTP VOUT N1 VDD VDD sky130_fd_pr__pfet_01v8 w=100 l=0.5 nf=1 m=20
XOUTN VOUT IBIAS VSS VSS sky130_fd_pr__nfet_01v8 w=100 l=1 nf=1 m=4
RCOMP N1 NC 500
CCOMP NC VOUT 15p
CBIAS IBIAS VSS 1p
.ends DUT
