.subckt DUT VIN VOUT VSS VREF
R1 VOUT FB 3Meg
R2 FB VSS 3Meg
RB VIN NB 5Meg
XM1 A FB TL VSS sky130_fd_pr__nfet_01v8 l=0.5 w=20 nf=1 m=2
XM2 X VREF TL VSS sky130_fd_pr__nfet_01v8 l=0.5 w=20 nf=1 m=2
XM3 A A VIN VIN sky130_fd_pr__pfet_01v8 l=0.5 w=4 nf=1 m=1
XM4 X A VIN VIN sky130_fd_pr__pfet_01v8 l=0.5 w=4 nf=1 m=1
XMB NB NB VSS VSS sky130_fd_pr__nfet_01v8 l=2 w=2 nf=1 m=1
XMP VOUT X VIN VIN sky130_fd_pr__pfet_01v8 l=0.25 w=12.5 nf=1 m=2
XMT TL NB VSS VSS sky130_fd_pr__nfet_01v8 l=2 w=2 nf=1 m=4
.ends DUT
