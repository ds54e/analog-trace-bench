.subckt DUT VINP VINN VOUT VDD VSS IBIAS
CC NZ VOUT 6p
RZ N1 NZ 930
XM1 NA VINN TAIL VSS sky130_fd_pr__nfet_01v8 l=1 w=50 nf=1 m=1
XM2 N1 VINP TAIL VSS sky130_fd_pr__nfet_01v8 l=1 w=50 nf=1 m=1
XM3 NA NA VDD VDD sky130_fd_pr__pfet_01v8 l=1 w=40 nf=1 m=2
XM4 N1 NA VDD VDD sky130_fd_pr__pfet_01v8 l=1 w=40 nf=1 m=2
XM6 VOUT N1 VDD VDD sky130_fd_pr__pfet_01v8 l=0.5 w=50 nf=1 m=11
XM7 VOUT IBIAS VSS VSS sky130_fd_pr__nfet_01v8 l=1 w=50 nf=1 m=20
XMREF IBIAS IBIAS VSS VSS sky130_fd_pr__nfet_01v8 l=1 w=10 nf=1 m=1
XMTAIL TAIL IBIAS VSS VSS sky130_fd_pr__nfet_01v8 l=1 w=10 nf=1 m=12
.ends DUT
