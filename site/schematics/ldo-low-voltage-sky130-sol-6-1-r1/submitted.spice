* PMOS LDO with matched two-stage error amplifier.
.subckt DUT VIN VOUT VSS VREF
Rref1 VREF VR 700k
Rref2 VR VSS 300k
Rfb1 VOUT FB 170k
Rfb2 FB VSS 30k
Rbleed VOUT VSS 100k
Rb VIN BN 150k
Xbn BN BN VSS VSS sky130_fd_pr__nfet_01v8 w=2 l=1 nf=1 m=1
Xbpm BP BP VIN VIN sky130_fd_pr__pfet_01v8 w=8 l=1 nf=1 m=1
Xbm BP BN VSS VSS sky130_fd_pr__nfet_01v8 w=2 l=1 nf=1 m=1
Xtail S BP VIN VIN sky130_fd_pr__pfet_01v8 w=48 l=1 nf=1 m=1
Xip D1 VR S VIN sky130_fd_pr__pfet_01v8 w=100 l=0.15 nf=1 m=2
Xim A FB S VIN sky130_fd_pr__pfet_01v8 w=100 l=0.15 nf=1 m=2
Xnd D1 D1 VSS VSS sky130_fd_pr__nfet_01v8 w=10 l=0.5 nf=1 m=1
Xno A QN VSS VSS sky130_fd_pr__nfet_01v8 w=10 l=0.5 nf=1 m=1
Xdrv G A VSS VSS sky130_fd_pr__nfet_01v8 w=33.333333 l=0.5 nf=1 m=1
Xpull G BP VIN VIN sky130_fd_pr__pfet_01v8 w=80 l=1 nf=1 m=1
Xpass VOUT G VIN VIN sky130_fd_pr__pfet_01v8 w=100 l=0.15 nf=1 m=8
Cvr VR VSS 5p
Cff VOUT FB 0.5p
Rq D1 QN 20k
Cq VOUT QN 1p

Rcm A AM 10k
Cm AM G 0.5p
.ends DUT
