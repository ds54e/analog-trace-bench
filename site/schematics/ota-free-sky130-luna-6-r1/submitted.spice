.subckt DUT VINP VINN VOUT VDD VSS IBIAS
* IBIAS reference and scaled NMOS current sinks
XMREF IBIAS IBIAS VSS VSS sky130_fd_pr__nfet_01v8 w=10 l=1 m=1
XMT TAIL IBIAS VSS VSS sky130_fd_pr__nfet_01v8 w=40 l=1 m=1
XM1 N1 VINP TAIL VSS sky130_fd_pr__nfet_01v8 w=20 l=1.5 m=1
XM2 ND VINN TAIL VSS sky130_fd_pr__nfet_01v8 w=20 l=1.5 m=1
* PMOS mirror load; ND is diode connected, N1 is the single-ended output
XMPD ND ND VDD VDD sky130_fd_pr__pfet_01v8 w=30 l=1.5 m=1
XMPM N1 ND VDD VDD sky130_fd_pr__pfet_01v8 w=30 l=1.5 m=1
* Class-A output stage, biased at approximately 228 uA
XMPO VOUT N1 VDD VDD sky130_fd_pr__pfet_01v8 w=45.5 l=1 m=5
XMNO VOUT IBIAS VSS VSS sky130_fd_pr__nfet_01v8 w=76 l=1 m=3
* Series-R Miller compensation to move the feed-forward zero leftward
CC N1 NC 2p
RZ NC VOUT 1.5k
.ends DUT
