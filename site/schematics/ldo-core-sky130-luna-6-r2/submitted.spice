.subckt DUT VIN VOUT VSS VREF
RBIAS VIN NBIAS 190k
XBIAS NBIAS NBIAS VSS VSS sky130_fd_pr__nfet_01v8 W=5 L=0.3
XTAIL NSRC NBIAS VSS VSS sky130_fd_pr__nfet_01v8 W=50 L=0.3
* Wider minimum-length NMOS input pair for process headroom and gm
XFB DFB VFB NSRC VSS sky130_fd_pr__nfet_01v8 W=100 L=0.15 m=2
XREF AMP VREF NSRC VSS sky130_fd_pr__nfet_01v8 W=100 L=0.15 m=2
XLOAD1 DFB DFB VIN VIN sky130_fd_pr__pfet_01v8 W=40 L=2
XLOAD2 AMP DFB VIN VIN sky130_fd_pr__pfet_01v8 W=40 L=2
XPASS VOUT AMP VIN VIN sky130_fd_pr__pfet_01v8 W=100 L=0.15 m=16
XPASS2 VOUT AMP VIN VIN sky130_fd_pr__pfet_01v8 W=100 L=0.15 m=8
RFTOP VOUT VFB 1.8245meg
RFBOT VFB VSS 2meg
CFF VOUT VFB 8p
CFAST VOUT NFAST 4p
RFAST NFAST AMP 30k
CSLOW VOUT NSLOW 5p
RSLOW NSLOW AMP 160k
RPULL AMP VIN 990k
RAMP AMP VSS 300k
RZ AMP NCOMP 15k
CCOMP NCOMP VOUT 3p
.ends DUT
