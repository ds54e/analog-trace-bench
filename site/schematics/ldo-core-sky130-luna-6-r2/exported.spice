.subckt DUT VIN VOUT VSS VREF
CCOMP NCOMP VOUT 3p
CFAST VOUT NFAST 4p
CFF VOUT VFB 8p
CSLOW VOUT NSLOW 5p
RAMP AMP VSS 300k
RBIAS VIN NBIAS 190k
RFAST NFAST AMP 30k
RFBOT VFB VSS 2meg
RFTOP VOUT VFB 1.8245meg
RPULL AMP VIN 990k
RSLOW NSLOW AMP 160k
RZ AMP NCOMP 15k
XBIAS NBIAS NBIAS VSS VSS sky130_fd_pr__nfet_01v8 l=0.3 w=5
XFB DFB VFB NSRC VSS sky130_fd_pr__nfet_01v8 l=0.15 w=100 m=2
XLOAD1 DFB DFB VIN VIN sky130_fd_pr__pfet_01v8 l=2 w=40
XLOAD2 AMP DFB VIN VIN sky130_fd_pr__pfet_01v8 l=2 w=40
XPASS VOUT AMP VIN VIN sky130_fd_pr__pfet_01v8 l=0.15 w=100 m=16
XPASS2 VOUT AMP VIN VIN sky130_fd_pr__pfet_01v8 l=0.15 w=100 m=8
XREF AMP VREF NSRC VSS sky130_fd_pr__nfet_01v8 l=0.15 w=100 m=2
XTAIL NSRC NBIAS VSS VSS sky130_fd_pr__nfet_01v8 l=0.3 w=50
.ends DUT
