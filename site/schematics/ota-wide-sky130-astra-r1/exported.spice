.subckt DUT VINP VINN VOUT VDD VSS IBIAS
CC CM VOUT 2.6p
CIN VINN IN 3.6p
CIP VINP IP 3.6p
RC G2 CM 2k
RGN IN VSS 372k
RGP IP VSS 372k
RIN VINN IN 828k
RIP VINP IP 828k
XBC BP IBIAS VSS VSS sky130_fd_pr__nfet_01v8 l=1 w=10 nf=1 m=1
XBCT BPT IBIAS VSS VSS sky130_fd_pr__nfet_01v8 l=1 w=10 nf=1 m=1
XBN IBIAS IBIAS VSS VSS sky130_fd_pr__nfet_01v8 l=1 w=10 nf=1 m=1
XBP BP BP VDD VDD sky130_fd_pr__pfet_01v8 l=1 w=20 nf=1 m=1
XBPT BPT BPT VDD VDD sky130_fd_pr__pfet_01v8 l=0.3 w=60 nf=1 m=1
XCN VDD IN VDD VDD sky130_fd_pr__pfet_01v8 l=6.05 w=100 nf=1 m=1
XCP VDD IP VDD VDD sky130_fd_pr__pfet_01v8 l=6.05 w=100 nf=1 m=1
XN1 D1 D1 VSS VSS sky130_fd_pr__nfet_01v8 l=0.5 w=100 nf=1 m=3
XN2 G2 D1 VSS VSS sky130_fd_pr__nfet_01v8 l=0.5 w=100 nf=1 m=3
XNO VOUT G2 VSS VSS sky130_fd_pr__nfet_01v8 l=0.5 w=100 nf=1 m=7
XP1 D1 IN ST VDD sky130_fd_pr__pfet_01v8 l=0.3 w=100 nf=1 m=7
XP2 G2 IP ST VDD sky130_fd_pr__pfet_01v8 l=0.3 w=100 nf=1 m=7
XPO VOUT BP VDD VDD sky130_fd_pr__pfet_01v8 l=1 w=20 nf=1 m=20
XPT ST BPT VDD VDD sky130_fd_pr__pfet_01v8 l=0.3 w=100 nf=1 m=7
.ends DUT
