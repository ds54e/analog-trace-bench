* Two-stage NMOS-input OTA with series-RC Miller compensation.
.subckt DUT VINP VINN VOUT VDD VSS IBIAS
XREF IBIAS IBIAS VSS VSS sky130_fd_pr__nfet_01v8 w=20 l=1 nf=1 m=1
XTAIL TAIL IBIAS VSS VSS sky130_fd_pr__nfet_01v8 w=80 l=1 nf=1 m=2
XIP N1 VINP TAIL VSS sky130_fd_pr__nfet_01v8 w=100 l=0.75 nf=1 m=2
XIN N2 VINN TAIL VSS sky130_fd_pr__nfet_01v8 w=100 l=0.75 nf=1 m=2
XP1 N1 N2 VDD VDD sky130_fd_pr__pfet_01v8 w=80 l=0.5 nf=1 m=1
XP2 N2 N2 VDD VDD sky130_fd_pr__pfet_01v8 w=80 l=0.5 nf=1 m=1
XOUT VOUT N1 VDD VDD sky130_fd_pr__pfet_01v8 w=85 l=0.5 nf=1 m=4
XSINK VOUT IBIAS VSS VSS sky130_fd_pr__nfet_01v8 w=85 l=1 nf=1 m=4
RZ N1 NC 1500
CC NC VOUT 4e-12
.ends DUT
