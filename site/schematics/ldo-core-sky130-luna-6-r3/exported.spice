.subckt DUT VIN VOUT VSS VREF
CCOMP NCOMP VOUT 6p
CFF VOUT VFB 13p
RBIAS VIN NBIAS 100k
RCOMP NG NCOMP 50k
RFB VFB VSS 1meg
RFT VOUT VFB 990k
XMBIAS NBIAS NBIAS VSS VSS sky130_fd_pr__nfet_01v8 l=0.5 w=40
XMFB NX VFB NTAIL VSS sky130_fd_pr__nfet_01v8 l=0.5 w=40
XMPASS VOUT NG VIN VIN sky130_fd_pr__pfet_01v8 l=0.15 w=100 m=4
XMPD NX NX VIN VIN sky130_fd_pr__pfet_01v8 l=0.5 w=10
XMPM NG NX VIN VIN sky130_fd_pr__pfet_01v8 l=0.5 w=10
XMREF NG VREF NTAIL VSS sky130_fd_pr__nfet_01v8 l=0.5 w=40
XMT NTAIL NBIAS VSS VSS sky130_fd_pr__nfet_01v8 l=0.5 w=80 m=2
.ends DUT
