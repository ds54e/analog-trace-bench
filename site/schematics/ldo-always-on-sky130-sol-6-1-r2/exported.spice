.subckt DUT VIN VOUT VSS VREF
CCOMP NC VIN 18p
RBIAS VIN BN 3.6meg
RCOMP PG NC 3meg
RFBB FB VSS 5meg
RFBT VOUT FB 4.92meg
RPG VIN PG 100meg
XBN BN BN VSS VSS sky130_fd_pr__nfet_01v8 l=2 w=1 nf=1 m=1
XNFB ND FB NT VSS sky130_fd_pr__nfet_01v8 l=0.5 w=50 nf=1 m=1
XNREF PG VREF NT VSS sky130_fd_pr__nfet_01v8 l=0.5 w=50 nf=1 m=1
XPASS VOUT PG VIN VIN sky130_fd_pr__pfet_01v8 l=0.15 w=30 nf=1 m=1
XPMD ND ND VIN VIN sky130_fd_pr__pfet_01v8 l=2 w=2 nf=1 m=1
XPMO PG ND VIN VIN sky130_fd_pr__pfet_01v8 l=2 w=2 nf=1 m=1
XTAIL NT BN VSS VSS sky130_fd_pr__nfet_01v8 l=2 w=3 nf=1 m=1
.ends DUT
