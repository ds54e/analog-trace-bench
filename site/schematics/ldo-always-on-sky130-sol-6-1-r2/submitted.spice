* Low-current PMOS LDO with output feedback and gate RC compensation
.subckt DUT VIN VOUT VSS VREF
RFBT VOUT FB 4.92meg
RFBB FB VSS 5meg
RBIAS VIN BN 3.6meg
XBN BN BN VSS VSS sky130_fd_pr__nfet_01v8 w=1 l=2 nf=1 m=1
XTAIL NT BN VSS VSS sky130_fd_pr__nfet_01v8 w=3 l=2 nf=1 m=1
XNREF PG VREF NT VSS sky130_fd_pr__nfet_01v8 w=50 l=0.5 nf=1 m=1
XNFB ND FB NT VSS sky130_fd_pr__nfet_01v8 w=50 l=0.5 nf=1 m=1
XPMD ND ND VIN VIN sky130_fd_pr__pfet_01v8 w=2 l=2 nf=1 m=1
XPMO PG ND VIN VIN sky130_fd_pr__pfet_01v8 w=2 l=2 nf=1 m=1
XPASS VOUT PG VIN VIN sky130_fd_pr__pfet_01v8 w=30 l=0.15 nf=1 m=1
RPG VIN PG 100meg
RCOMP PG NC 3meg
CCOMP NC VIN 18p
.ends DUT
