.subckt DUT VIN VOUT VSS VREF
CCOMP CZ VSS 50p
CEA EA VSS 3p
CFB VOUT FB 47p
RB PB VSS 210k
RCOMP EA CZ 200k
RFB1 VOUT FB 20k
RFB2 FB VSS 20k
RSF SF VSS 25k
RSR SR VSS 25k
XDR PG EA VSS VSS sky130_fd_pr__nfet_01v8 l=0.5 w=30 nf=1 m=1
XNL1 ND ND VSS VSS sky130_fd_pr__nfet_01v8 l=10 w=100 nf=1 m=1
XNL2 EA ND VSS VSS sky130_fd_pr__nfet_01v8 l=10 w=100 nf=1 m=1
XPASS VOUT PG VIN VIN sky130_fd_pr__pfet_01v8 l=0.5 w=100 nf=1 m=24
XPB PB PB VIN VIN sky130_fd_pr__pfet_01v8 l=1 w=100 nf=1 m=1
XPI1 ND SR TS VIN sky130_fd_pr__pfet_01v8 l=1 w=100 nf=1 m=8
XPI2 EA SF TS VIN sky130_fd_pr__pfet_01v8 l=1 w=100 nf=1 m=8
XPT TS PB VIN VIN sky130_fd_pr__pfet_01v8 l=1 w=100 nf=1 m=8
XREP PG PG VIN VIN sky130_fd_pr__pfet_01v8 l=0.5 w=100 nf=1 m=1
XSF VIN FB SF VSS sky130_fd_pr__nfet_01v8 l=0.5 w=100 nf=1 m=32
XSR VIN VREF SR VSS sky130_fd_pr__nfet_01v8 l=0.5 w=100 nf=1 m=32
.ends DUT
