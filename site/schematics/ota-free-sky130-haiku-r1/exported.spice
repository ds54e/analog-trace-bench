.subckt DUT VINP VINN VOUT VDD VSS IBIAS
CC nb nz 1p
RZ nz VOUT 3k
XM1 na VINN tail VSS sky130_fd_pr__nfet_01v8 l=1 w=40 nf=1 m=1
XM2 nb VINP tail VSS sky130_fd_pr__nfet_01v8 l=1 w=40 nf=1 m=1
XM3 na na VDD VDD sky130_fd_pr__pfet_01v8 l=0.5 w=20 nf=1 m=1
XM4 nb na VDD VDD sky130_fd_pr__pfet_01v8 l=0.5 w=20 nf=1 m=1
XM6 VOUT nb VDD VDD sky130_fd_pr__pfet_01v8 l=0.25 w=100 nf=1 m=1
XMOUT VOUT IBIAS VSS VSS sky130_fd_pr__nfet_01v8 l=0.5 w=100 nf=1 m=1
XMREF IBIAS IBIAS VSS VSS sky130_fd_pr__nfet_01v8 l=1 w=10 nf=1 m=1
XMTAIL tail IBIAS VSS VSS sky130_fd_pr__nfet_01v8 l=1 w=20 nf=1 m=1
.ends DUT
