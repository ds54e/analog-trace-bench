* OTA variant
.subckt DUT VINP VINN VOUT VDD VSS IBIAS
XMREF IBIAS IBIAS VSS VSS sky130_fd_pr__nfet_01v8 W=10 L=1 m=1 nf=1
XMTAIL tail IBIAS VSS VSS sky130_fd_pr__nfet_01v8 W=20 L=1 m=1 nf=1
XMOUT VOUT IBIAS VSS VSS sky130_fd_pr__nfet_01v8 W=100 L=0.5 m=1 nf=1
XM1 na VINN tail VSS sky130_fd_pr__nfet_01v8 W=40 L=1 m=1 nf=1
XM2 nb VINP tail VSS sky130_fd_pr__nfet_01v8 W=40 L=1 m=1 nf=1
XM3 na na VDD VDD sky130_fd_pr__pfet_01v8 W=20 L=0.5 m=1 nf=1
XM4 nb na VDD VDD sky130_fd_pr__pfet_01v8 W=20 L=0.5 m=1 nf=1
XM6 VOUT nb VDD VDD sky130_fd_pr__pfet_01v8 W=100 L=0.25 m=1 nf=1
CC nb nz 1p
RZ nz VOUT 3k
.ends DUT
