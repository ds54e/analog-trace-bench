* Folded error amplifier and local pass-gate servo.
.subckt DUT VIN VOUT VSS VREF
* Supply-derived reference current.
RBIAS VIN BN 550k
XBN BN BN VSS VSS sky130_fd_pr__nfet_01v8 w=20 l=10 nf=1 m=1
XNB BP BN VSS VSS sky130_fd_pr__nfet_01v8 w=20 l=10 nf=1 m=1
XPB BP BP VIN VIN sky130_fd_pr__pfet_01v8 w=100 l=1 nf=1 m=2
* Wide-swing PMOS mirror bias.
RPC BP PC 1k
XNPC PC BN VSS VSS sky130_fd_pr__nfet_01v8 w=20 l=10 nf=1 m=1
* Folded-branch common-gate bias, with negligible reference loading.
RNC VIN NC 5meg
XNC NC NC VREF VSS sky130_fd_pr__nfet_01v8 w=100 l=0.15 nf=1 m=4
* PMOS input pair and folded branch current sinks.
XIT ST BP VIN VIN sky130_fd_pr__pfet_01v8 w=100 l=1 nf=1 m=10
XIF D1 FB ST VIN sky130_fd_pr__pfet_01v8 w=100 l=0.15 nf=1 m=16
XIR D2 VREF ST VIN sky130_fd_pr__pfet_01v8 w=100 l=0.15 nf=1 m=16
XNS1 D1 BN VSS VSS sky130_fd_pr__nfet_01v8 w=20 l=10 nf=1 m=6
XNS2 D2 BN VSS VSS sky130_fd_pr__nfet_01v8 w=20 l=10 nf=1 m=6
XNF1 PM NC D1 VSS sky130_fd_pr__nfet_01v8 w=100 l=0.5 nf=1 m=1
XNF2 EA NC D2 VSS sky130_fd_pr__nfet_01v8 w=100 l=0.5 nf=1 m=1
* Cascoded folding mirror provides gain and a wide output range.
XPM1 U1 PM VIN VIN sky130_fd_pr__pfet_01v8 w=100 l=0.5 nf=1 m=14
XPC1 PM PC U1 VIN sky130_fd_pr__pfet_01v8 w=100 l=0.5 nf=1 m=14
XPM2 U2 PM VIN VIN sky130_fd_pr__pfet_01v8 w=100 l=0.5 nf=1 m=14
XPC2 EA PC2 U2 VIN sky130_fd_pr__pfet_01v8 w=100 l=0.5 nf=1 m=14
RCP1 PC PC2 1meg
RCP2 VIN PC2 24meg
* NMOS local voltage follower with a low-compliance tail.
XPBB BNB BP VIN VIN sky130_fd_pr__pfet_01v8 w=100 l=1 nf=1 m=4
XNBB BNB BNB VSS VSS sky130_fd_pr__nfet_01v8 w=100 l=1 nf=1 m=2
XBT SN BNB VSS VSS sky130_fd_pr__nfet_01v8 w=100 l=1 nf=1 m=8
XB1 PB EA SN VSS sky130_fd_pr__nfet_01v8 w=100 l=0.15 nf=1 m=8
XB2 PG BG SN VSS sky130_fd_pr__nfet_01v8 w=100 l=0.15 nf=1 m=8
XBP1 PB PB VIN VIN sky130_fd_pr__pfet_01v8 w=100 l=0.15 nf=1 m=8
XBP2 PG PB VIN VIN sky130_fd_pr__pfet_01v8 w=100 l=0.15 nf=1 m=8
RGB1 PG BG 100k
RGB2 VIN BG 300k
* Low-dropout pass, feedback lead, and supply feedforward compensation.
XPP VOUT PG VIN VIN sky130_fd_pr__pfet_01v8 w=100 l=0.15 nf=1 m=32
RFT VOUT FB 100k
RFB FB VSS 100k
CFF VOUT FB 88p
RCOMP EA XC 70k
CCOMP XC VIN 12p
.ends DUT
