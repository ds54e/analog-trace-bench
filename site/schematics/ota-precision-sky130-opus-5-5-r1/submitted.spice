* Folded-cascode (NMOS input) + NMOS CS output, Miller compensated
.subckt DUT VINP VINN VOUT VDD VSS IBIAS
XMB0 IBIAS IBIAS VSS VSS sky130_fd_pr__nfet_01v8 W=20 L=2 nf=1 m=1
XMB1 VBP2 IBIAS VSS VSS sky130_fd_pr__nfet_01v8 W=20 L=2 nf=1 m=1
XMB2 VBP1 VBP1 VDD VDD sky130_fd_pr__pfet_01v8 W=12 L=4 nf=1 m=1
R1 VBP1 VBP2 25k
XMB7 VBN2 VBP1 VDD VDD sky130_fd_pr__pfet_01v8 W=12 L=4 nf=1 m=1
R2 VBN2 VBN2A 40k
XMB6 VBN2A VBN2A VSS VSS sky130_fd_pr__nfet_01v8 W=5 L=0.5 nf=1 m=1
XM0 S IBIAS VSS VSS sky130_fd_pr__nfet_01v8 W=20 L=2 nf=1 m=4
XM1 F1 VINN S VSS sky130_fd_pr__nfet_01v8 W=50 L=2 nf=1 m=4
XM2 F2 VINP S VSS sky130_fd_pr__nfet_01v8 W=50 L=2 nf=1 m=4
XM3 F1 VBP1 VDD VDD sky130_fd_pr__pfet_01v8 W=12 L=4 nf=1 m=4
XM4 F2 VBP1 VDD VDD sky130_fd_pr__pfet_01v8 W=12 L=4 nf=1 m=4
XM5 D1 VBP2 F1 VDD sky130_fd_pr__pfet_01v8 W=20 L=0.5 nf=1 m=1
XM6 X VBP2 F2 VDD sky130_fd_pr__pfet_01v8 W=20 L=0.5 nf=1 m=1
XM7 D1 VBN2 P1 VSS sky130_fd_pr__nfet_01v8 W=10 L=0.5 nf=1 m=1
XM8 X VBN2 P2 VSS sky130_fd_pr__nfet_01v8 W=10 L=0.5 nf=1 m=1
XM9 P1 D1 VSS VSS sky130_fd_pr__nfet_01v8 W=24 L=6 nf=1 m=1
XM10 P2 D1 VSS VSS sky130_fd_pr__nfet_01v8 W=24 L=6 nf=1 m=1
XM11 VOUT X VSS VSS sky130_fd_pr__nfet_01v8 W=16 L=0.5 nf=1 m=1
XM12 VOUT VBP1 VDD VDD sky130_fd_pr__pfet_01v8 W=12 L=4 nf=1 m=12
RZ X XZ 1.2k
CC XZ VOUT 16p
.ends DUT
