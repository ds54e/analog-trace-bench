* LDO core: single-stage error amp, PMOS pass, Miller cap from gate to VOUT
.subckt DUT VIN VOUT VSS VREF
R1 VOUT FB 400000
R2 FB VSS 400000
XM1 D1 FB TL VSS sky130_fd_pr__nfet_01v8 W=8 L=1 m=1
XM2 GA VREF TL VSS sky130_fd_pr__nfet_01v8 W=8 L=1 m=1
XM3 D1 D1 VIN VIN sky130_fd_pr__pfet_01v8 W=4 L=1 m=1
XM4 GA D1 VIN VIN sky130_fd_pr__pfet_01v8 W=4 L=1 m=1
XM5 TL VB VSS VSS sky130_fd_pr__nfet_01v8 W=4 L=1 m=1
XM6 VB VB VSS VSS sky130_fd_pr__nfet_01v8 W=4 L=1 m=1
R3 VIN VB 80000
R4 VOUT VSS 68000
XMP VOUT GA VIN VIN sky130_fd_pr__pfet_01v8 W=99 L=0.15 m=8
CC GA VOUT 1e-11
.ends DUT
