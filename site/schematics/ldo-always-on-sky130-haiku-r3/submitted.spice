* Always-on LDO: PMOS pass, 5T error amplifier, resistive bias, 2:1 divider
.subckt DUT VIN VOUT VSS VREF
XMP VOUT GATE VIN VIN sky130_fd_pr__pfet_01v8 W=10 L=0.15 nf=1 m=1
XM1 D1 FB TAIL VSS sky130_fd_pr__nfet_01v8 W=4 L=0.6 nf=1 m=1
XM2 GATE VREF TAIL VSS sky130_fd_pr__nfet_01v8 W=4 L=0.6 nf=1 m=1
XM3 D1 D1 VIN VIN sky130_fd_pr__pfet_01v8 W=4 L=0.6 nf=1 m=1
XM4 GATE D1 VIN VIN sky130_fd_pr__pfet_01v8 W=4 L=0.6 nf=1 m=1
XM5 TAIL BIAS VSS VSS sky130_fd_pr__nfet_01v8 W=4 L=0.5 nf=1 m=1
XMB BIAS BIAS VSS VSS sky130_fd_pr__nfet_01v8 W=4 L=0.5 nf=1 m=1
RB VIN BIAS 1.9meg
R1 VOUT FB 5meg
R2 FB VSS 5meg
.ends DUT
