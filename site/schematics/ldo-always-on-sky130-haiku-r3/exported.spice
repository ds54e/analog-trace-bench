.subckt DUT VIN VOUT VSS VREF
R1 VOUT FB 5meg
R2 FB VSS 5meg
RB VIN BIAS 1.9meg
XM1 D1 FB TAIL VSS sky130_fd_pr__nfet_01v8 l=0.6 w=4 nf=1 m=1
XM2 GATE VREF TAIL VSS sky130_fd_pr__nfet_01v8 l=0.6 w=4 nf=1 m=1
XM3 D1 D1 VIN VIN sky130_fd_pr__pfet_01v8 l=0.6 w=4 nf=1 m=1
XM4 GATE D1 VIN VIN sky130_fd_pr__pfet_01v8 l=0.6 w=4 nf=1 m=1
XM5 TAIL BIAS VSS VSS sky130_fd_pr__nfet_01v8 l=0.5 w=4 nf=1 m=1
XMB BIAS BIAS VSS VSS sky130_fd_pr__nfet_01v8 l=0.5 w=4 nf=1 m=1
XMP VOUT GATE VIN VIN sky130_fd_pr__pfet_01v8 l=0.15 w=10 nf=1 m=1
.ends DUT
