.subckt DUT VIN VOUT VSS VREF
RF1 VOUT VFB 50k
RF2 VFB VSS 50k
RB VIN VB 150k
XM6 VB VB VSS VSS sky130_fd_pr__nfet_01v8 W=5 L=1 nf=1 m=1
XM5 TAIL VB VSS VSS sky130_fd_pr__nfet_01v8 W=40 L=1 nf=1 m=1
XM1 X VFB TAIL VSS sky130_fd_pr__nfet_01v8 W=20 L=0.35 nf=1 m=1
XM2 VG VREF TAIL VSS sky130_fd_pr__nfet_01v8 W=20 L=0.35 nf=1 m=1
XM3 X X VIN VIN sky130_fd_pr__pfet_01v8 W=20 L=0.5 nf=1 m=1
XM4 VG X VIN VIN sky130_fd_pr__pfet_01v8 W=20 L=0.5 nf=1 m=1
XMP VOUT VG VIN VIN sky130_fd_pr__pfet_01v8 W=90 L=0.15 nf=1 m=1
CM VG VOUT 0.1p
.ends DUT
