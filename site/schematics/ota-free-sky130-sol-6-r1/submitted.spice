* NMOS-input folded-cascode OTA with cascoded bottom current mirror
.subckt DUT VINP VINN VOUT VDD VSS IBIAS
* Reference current and PMOS bias
XNR IBIAS IBIAS VSS VSS sky130_fd_pr__nfet_01v8 w=10 l=1 m=1
XNPREF BP IBIAS VSS VSS sky130_fd_pr__nfet_01v8 w=10 l=1 m=1
XPREF BP BP VDD VDD sky130_fd_pr__pfet_01v8 w=20 l=1 m=1
* Supply-referred gate bias leaves headroom at low VDD
RFBU VDD FBG 820k
RFBL FBG VSS 180k
* Bias for bottom NMOS cascodes
XPCB NC BP VDD VDD sky130_fd_pr__pfet_01v8 w=20 l=1 m=1
XNBL NB NB VSS VSS sky130_fd_pr__nfet_01v8 w=20 l=0.5 m=1
XNBU NC NC NB VSS sky130_fd_pr__nfet_01v8 w=20 l=0.5 m=1
* Differential input pair, 100 uA tail
XNTAIL TAIL IBIAS VSS VSS sky130_fd_pr__nfet_01v8 w=10 l=1 m=10
XNINP FD1 VINP TAIL VSS sky130_fd_pr__nfet_01v8 w=80 l=0.5 m=1
XNINN FD2 VINN TAIL VSS sky130_fd_pr__nfet_01v8 w=80 l=0.5 m=1
* Each PMOS source supplies about 100 uA; roughly 50 uA folds
XPCS1 FD1 BP VDD VDD sky130_fd_pr__pfet_01v8 w=20 l=1 m=10
XPCS2 FD2 BP VDD VDD sky130_fd_pr__pfet_01v8 w=20 l=1 m=10
XPFO1 ND1 FBG FD1 VDD sky130_fd_pr__pfet_01v8 w=100 l=0.5 m=1
XPFO2 VOUT FBG FD2 VDD sky130_fd_pr__pfet_01v8 w=100 l=0.5 m=1
* Cascoded mirror converts the differential folded currents to VOUT
XNML BNL BNL VSS VSS sky130_fd_pr__nfet_01v8 w=100 l=1 m=4
XNCL ND1 NC BNL VSS sky130_fd_pr__nfet_01v8 w=100 l=0.5 m=2
XNMR BNR BNL VSS VSS sky130_fd_pr__nfet_01v8 w=100 l=1 m=4
XNCR VOUT NC BNR VSS sky130_fd_pr__nfet_01v8 w=100 l=0.5 m=2
CDAMP VOUT VSS 1.3p
.ends DUT
