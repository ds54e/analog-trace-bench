* Low-current single-stage error amplifier and PMOS pass regulator.
.subckt DUT VIN VOUT VSS VREF
RFBT VOUT FB 5.91meg
RFBB FB VSS 6meg
RBIAS VIN BN 3meg
XBN BN BN VSS VSS sky130_fd_pr__nfet_01v8 w=2 l=2 nf=1 m=1
XTAIL NS BN VSS VSS sky130_fd_pr__nfet_01v8 w=4 l=2 nf=1 m=1
XFB ND FB NS VSS sky130_fd_pr__nfet_01v8 w=20 l=0.5 nf=1 m=1
XREF PG VREF NS VSS sky130_fd_pr__nfet_01v8 w=20 l=0.5 nf=1 m=1
XPD ND ND VIN VIN sky130_fd_pr__pfet_01v8 w=4 l=2 nf=1 m=1
XPM PG ND VIN VIN sky130_fd_pr__pfet_01v8 w=4 l=2 nf=1 m=1
XPASS VOUT PG VIN VIN sky130_fd_pr__pfet_01v8 w=30 l=0.15 nf=1 m=2
CFF VOUT FB 2p
.ends DUT
