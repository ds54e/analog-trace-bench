* Folded-cascode OTA, NMOS input pair, wide-swing NMOS cascode mirror load
.subckt DUT VINP VINN VOUT VDD VSS IBIAS
* reference diode and tail
XMB0 IBIAS IBIAS VSS VSS sky130_fd_pr__nfet_01v8 W=16 L=1 nf=1 m=1
XMT TAIL IBIAS VSS VSS sky130_fd_pr__nfet_01v8 W=16 L=1 nf=1 m=9
* input pair
XM1 F1 VINP TAIL VSS sky130_fd_pr__nfet_01v8 W=60 L=0.5 nf=1 m=2
XM2 F2 VINN TAIL VSS sky130_fd_pr__nfet_01v8 W=60 L=0.5 nf=1 m=2
* top PMOS current sources
XM3 F1 PB VDD VDD sky130_fd_pr__pfet_01v8 W=16 L=1 nf=1 m=10
XM4 F2 PB VDD VDD sky130_fd_pr__pfet_01v8 W=16 L=1 nf=1 m=10
* PMOS cascodes
XM5 Y1 PCB F1 VDD sky130_fd_pr__pfet_01v8 W=50 L=0.5 nf=1 m=2
XM6 VOUT PCB F2 VDD sky130_fd_pr__pfet_01v8 W=50 L=0.5 nf=1 m=2
* NMOS cascodes
XM7 Y1 NCB N1 VSS sky130_fd_pr__nfet_01v8 W=50 L=0.5 nf=1 m=1
XM8 VOUT NCB N2 VSS sky130_fd_pr__nfet_01v8 W=50 L=0.5 nf=1 m=1
* NMOS mirror
XM9 N1 Y1 VSS VSS sky130_fd_pr__nfet_01v8 W=50 L=1 nf=1 m=1
XM10 N2 Y1 VSS VSS sky130_fd_pr__nfet_01v8 W=50 L=1 nf=1 m=1
* bias leg: PB
XMN1 PB IBIAS VSS VSS sky130_fd_pr__nfet_01v8 W=16 L=1 nf=1 m=1
XMP1 PB PB VDD VDD sky130_fd_pr__pfet_01v8 W=16 L=1 nf=1 m=1
* bias leg: PCB
RC VDD PS 70k
XMPC PCB PCB PS VDD sky130_fd_pr__pfet_01v8 W=9 L=0.5 nf=1 m=1
XMN2 PCB IBIAS VSS VSS sky130_fd_pr__nfet_01v8 W=8 L=1 nf=1 m=1
* bias leg: NCB
XMP2 NCB PB VDD VDD sky130_fd_pr__pfet_01v8 W=8 L=1 nf=1 m=1
XMNX NCB NCB QR VSS sky130_fd_pr__nfet_01v8 W=4.5 L=0.5 nf=1 m=1
RQ QR VSS 50k
.ends DUT
