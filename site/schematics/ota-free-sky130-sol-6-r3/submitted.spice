* Two-stage CMOS OTA with level-shifted PMOS differential input
.subckt DUT VINP VINN VOUT VDD VSS IBIAS
* Ground-referenced current reference and mirrors
XBN IBIAS IBIAS VSS VSS sky130_fd_pr__nfet_01v8 w=10 l=1 m=1
XBPULL PB IBIAS VSS VSS sky130_fd_pr__nfet_01v8 w=10 l=1 m=1
XSINK1 IN1 IBIAS VSS VSS sky130_fd_pr__nfet_01v8 w=30 l=1 m=1
XSINK2 IN2 IBIAS VSS VSS sky130_fd_pr__nfet_01v8 w=30 l=1 m=1
* Source-following input level shifts
XSF1 VDD VINN IN1 VSS sky130_fd_pr__nfet_01v8 w=50 l=0.5 m=4
XSF2 VDD VINP IN2 VSS sky130_fd_pr__nfet_01v8 w=50 l=0.5 m=4
* Supply-referenced PMOS tail and output currents
XPBIAS PB PB VDD VDD sky130_fd_pr__pfet_01v8 w=10 l=1 m=1
XPTAIL STAIL PB VDD VDD sky130_fd_pr__pfet_01v8 w=10 l=1 m=10
XPOUT VOUT PB VDD VDD sky130_fd_pr__pfet_01v8 w=10 l=1 m=2
XPBOOST VOUT GB VDD VDD sky130_fd_pr__pfet_01v8 w=100 l=1 m=1
RB GB PB 10k
CB GB N2 1.1p
* Differential first stage with ground-referenced NMOS mirror
XPINN N1 IN1 STAIL VDD sky130_fd_pr__pfet_01v8 w=100 l=0.5 m=1
XPINP N2 IN2 STAIL VDD sky130_fd_pr__pfet_01v8 w=100 l=0.5 m=1
XNM1 N1 N1 VSS VSS sky130_fd_pr__nfet_01v8 w=20 l=1 m=1
XNM2 N2 N1 VSS VSS sky130_fd_pr__nfet_01v8 w=20.4 l=1 m=1
* Class-A output and Miller compensation
XNOUT VOUT N2 VSS VSS sky130_fd_pr__nfet_01v8 w=100 l=0.5 m=2
RZ N2 NZ 1500
CC NZ VOUT 3.8p
.ends DUT
