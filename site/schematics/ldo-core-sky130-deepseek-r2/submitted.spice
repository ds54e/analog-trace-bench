* LDO core v1 : PMOS pass, 5T OTA with load-tracking tail, Miller comp
.subckt DUT VIN VOUT VSS VREF
Rfb1 VOUT FB 300k
Rfb2 FB VSS 300k
XMp VOUT G VIN VIN sky130_fd_pr__pfet_01v8 w=100 l=0.15 m=6
Ccomp G VOUT 20p
XM1 A FB TAIL VIN sky130_fd_pr__pfet_01v8 w=20 l=1 m=1
XM2 G VREF TAIL VIN sky130_fd_pr__pfet_01v8 w=20 l=1 m=1
XM3 A A VSS VSS sky130_fd_pr__nfet_01v8 w=100 l=8 m=1
XM4 G A VSS VSS sky130_fd_pr__nfet_01v8 w=100 l=8 m=1
XM5 TAIL G VIN VIN sky130_fd_pr__pfet_01v8 w=12 l=0.15 m=1
Rbias VIN NB 90k
XM6 NB NB VSS VSS sky130_fd_pr__nfet_01v8 w=10 l=1 m=2
XM7 NB2 NB VSS VSS sky130_fd_pr__nfet_01v8 w=10 l=1 m=2
XM8 NB2 NB2 VIN VIN sky130_fd_pr__pfet_01v8 w=10 l=1 m=2
XM9 TAIL NB2 VIN VIN sky130_fd_pr__pfet_01v8 w=10 l=1 m=2
.ends DUT
