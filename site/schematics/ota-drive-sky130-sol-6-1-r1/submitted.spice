* Two-stage OTA with resistive Miller compensation
.subckt DUT VINP VINN VOUT VDD VSS IBIAS
XREF IBIAS IBIAS VSS VSS sky130_fd_pr__nfet_01v8 w=10 l=1 nf=1 m=1
XTAIL TAIL IBIAS VSS VSS sky130_fd_pr__nfet_01v8 w=100 l=1 nf=1 m=2
XIP A VINP TAIL VSS sky130_fd_pr__nfet_01v8 w=100 l=0.5 nf=1 m=4
XIN D VINN TAIL VSS sky130_fd_pr__nfet_01v8 w=100 l=0.5 nf=1 m=4
XPD D D VDD VDD sky130_fd_pr__pfet_01v8 w=100 l=0.5 nf=1 m=1
XPM A D VDD VDD sky130_fd_pr__pfet_01v8 w=100 l=0.5 nf=1 m=1
XOUTP VOUT A VDD VDD sky130_fd_pr__pfet_01v8 w=100 l=0.5 nf=1 m=10
XOUTN VOUT IBIAS VSS VSS sky130_fd_pr__nfet_01v8 w=100 l=1 nf=1 m=10
RZ A CC 450
CM CC VOUT 12p
.ends DUT
