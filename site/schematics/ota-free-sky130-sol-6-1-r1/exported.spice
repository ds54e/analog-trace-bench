.subckt DUT VINP VINN VOUT VDD VSS IBIAS
CC NC VOUT 4.5p
RZ NG NC 1000
XINN ND VINN NT VSS sky130_fd_pr__nfet_01v8 l=0.5 w=60 nf=1 m=1
XINP NG VINP NT VSS sky130_fd_pr__nfet_01v8 l=0.5 w=60 nf=1 m=1
XOUTN VOUT IBIAS VSS VSS sky130_fd_pr__nfet_01v8 l=1 w=75 nf=1 m=10
XOUTP VOUT NG VDD VDD sky130_fd_pr__pfet_01v8 l=0.5 w=100 nf=1 m=3
XPL ND ND VDD VDD sky130_fd_pr__pfet_01v8 l=0.5 w=80 nf=1 m=1
XPR NG ND VDD VDD sky130_fd_pr__pfet_01v8 l=0.5 w=80 nf=1 m=1
XREF IBIAS IBIAS VSS VSS sky130_fd_pr__nfet_01v8 l=1 w=50 nf=1 m=1
XTAIL NT IBIAS VSS VSS sky130_fd_pr__nfet_01v8 l=1 w=100 nf=1 m=4
.ends DUT
