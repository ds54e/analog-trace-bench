* NMOS-input folded-cascode first stage + NMOS CS second stage, Miller Cc + Rz
.subckt DUT VINP VINN VOUT VDD VSS IBIAS
* bias: IREF into NMOS diode; PMOS diode + resistor for cascode gate
XMB1 IBIAS IBIAS VSS VSS sky130_fd_pr__nfet_01v8 W=20 L=2 nf=1 m=1
XMB2 vbpc IBIAS VSS VSS sky130_fd_pr__nfet_01v8 W=20 L=2 nf=1 m=1
XMB3 vbp vbp VDD VDD sky130_fd_pr__pfet_01v8 W=15 L=2.5 nf=1 m=1
Rb vbp vbpc 15k
* input pair (VINP on output side)
XM0 tail IBIAS VSS VSS sky130_fd_pr__nfet_01v8 W=20 L=2 nf=1 m=4
XM1 fa VINN tail VSS sky130_fd_pr__nfet_01v8 W=80 L=1 nf=1 m=1
XM2 fb VINP tail VSS sky130_fd_pr__nfet_01v8 W=80 L=1 nf=1 m=1
* folded cascode
XM3 fa vbp VDD VDD sky130_fd_pr__pfet_01v8 W=15 L=2.5 nf=1 m=4
XM4 fb vbp VDD VDD sky130_fd_pr__pfet_01v8 W=15 L=2.5 nf=1 m=4
XM5 c vbpc fa VDD sky130_fd_pr__pfet_01v8 W=30 L=0.5 nf=1 m=1
XM6 x vbpc fb VDD sky130_fd_pr__pfet_01v8 W=30 L=0.5 nf=1 m=1
XM7 c c s7 VSS sky130_fd_pr__nfet_01v8 W=20 L=2 nf=1 m=1
XM8 x c s8 VSS sky130_fd_pr__nfet_01v8 W=20 L=2 nf=1 m=1
R7 s7 VSS 2k
R8 s8 VSS 2k
* output stage
XM9 VOUT x VSS VSS sky130_fd_pr__nfet_01v8 W=54 L=1 nf=1 m=1
XM10 VOUT vbp VDD VDD sky130_fd_pr__pfet_01v8 W=15 L=2.5 nf=1 m=18
Rz x nz 2.5k
Cc nz VOUT 2p
.ends DUT
