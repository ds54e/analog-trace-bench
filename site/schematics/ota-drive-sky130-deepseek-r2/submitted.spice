* OTA-DRIVE-SKY130 : single-stage folded-cascode OTA (final)
* IBIAS 10uA -> VBN -> tail ~0.5mA/device pair, folded cascode, NMOS mirror output
.subckt DUT VINP VINN VOUT VDD VSS IBIAS
XMB0 IBIAS IBIAS VSS VSS sky130_fd_pr__nfet_01v8 W=10 L=0.5 nf=1 m=1
RG IBIAS VBN 10000
XM0 TAIL VBN VSS VSS sky130_fd_pr__nfet_01v8 W=100 L=0.485 nf=1 m=10
XMB2 VBC VBN VSS VSS sky130_fd_pr__nfet_01v8 W=10 L=0.5 nf=1 m=1
XMB3 VBP VBN VSS VSS sky130_fd_pr__nfet_01v8 W=17 L=0.5 nf=1 m=1
R1 VBP VBC 32000
XMP0 VBP VBP VDD VDD sky130_fd_pr__pfet_01v8 W=15 L=0.25 nf=1 m=1
XM3 F1 VBP VDD VDD sky130_fd_pr__pfet_01v8 W=100 L=0.25 nf=1 m=5
XM4 F2 VBP VDD VDD sky130_fd_pr__pfet_01v8 W=100 L=0.25 nf=1 m=5
XM5 VOUT VBC F1 VDD sky130_fd_pr__pfet_01v8 W=50 L=0.5 nf=1 m=8
XM6 C2 VBC F2 VDD sky130_fd_pr__pfet_01v8 W=50 L=0.5 nf=1 m=8
XM1 F1 VINN TAIL VSS sky130_fd_pr__nfet_01v8 W=100 L=0.25 nf=1 m=12
XM2 F2 VINP TAIL VSS sky130_fd_pr__nfet_01v8 W=100 L=0.25 nf=1 m=12
XM7 C2 C2 VSS VSS sky130_fd_pr__nfet_01v8 W=100 L=1.5 nf=1 m=4
XM8 VOUT C2 VSS VSS sky130_fd_pr__nfet_01v8 W=100 L=1.5 nf=1 m=4
.ends DUT
