.subckt DUT VINP VINN VOUT VDD VSS IBIAS
R1 VBP VBC 32000
RG IBIAS VBN 10000
XM0 TAIL VBN VSS VSS sky130_fd_pr__nfet_01v8 l=0.485 w=100 nf=1 m=10
XM1 F1 VINN TAIL VSS sky130_fd_pr__nfet_01v8 l=0.25 w=100 nf=1 m=12
XM2 F2 VINP TAIL VSS sky130_fd_pr__nfet_01v8 l=0.25 w=100 nf=1 m=12
XM3 F1 VBP VDD VDD sky130_fd_pr__pfet_01v8 l=0.25 w=100 nf=1 m=5
XM4 F2 VBP VDD VDD sky130_fd_pr__pfet_01v8 l=0.25 w=100 nf=1 m=5
XM5 VOUT VBC F1 VDD sky130_fd_pr__pfet_01v8 l=0.5 w=50 nf=1 m=8
XM6 C2 VBC F2 VDD sky130_fd_pr__pfet_01v8 l=0.5 w=50 nf=1 m=8
XM7 C2 C2 VSS VSS sky130_fd_pr__nfet_01v8 l=1.5 w=100 nf=1 m=4
XM8 VOUT C2 VSS VSS sky130_fd_pr__nfet_01v8 l=1.5 w=100 nf=1 m=4
XMB0 IBIAS IBIAS VSS VSS sky130_fd_pr__nfet_01v8 l=0.5 w=10 nf=1 m=1
XMB2 VBC VBN VSS VSS sky130_fd_pr__nfet_01v8 l=0.5 w=10 nf=1 m=1
XMB3 VBP VBN VSS VSS sky130_fd_pr__nfet_01v8 l=0.5 w=17 nf=1 m=1
XMP0 VBP VBP VDD VDD sky130_fd_pr__pfet_01v8 l=0.25 w=15 nf=1 m=1
.ends DUT
