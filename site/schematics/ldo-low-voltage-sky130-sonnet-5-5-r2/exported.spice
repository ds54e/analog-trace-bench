.subckt DUT VIN VOUT VSS VREF
C1 VOUT NFB 0.6p
C2 NFB VSS 1.0p
C3 VREF NRF 0.6p
C4 NRF VSS 1.4p
CZ NZ VSS 0.1p
R1 VOUT NFB 6.667meg
R2 NFB VSS 1.176meg
R3 VREF NRF 3.333meg
R4 NRF VSS 1.4393meg
RB NB VSS 50k
RS VIN TS 1
RZ X NZ 100k
XM1 D1 NRF TAIL VIN sky130_fd_pr__pfet_01v8 l=0.5 w=100 m=2
XM2 X NFB TAIL VIN sky130_fd_pr__pfet_01v8 l=0.5 w=100 m=2
XM3 D1 D1 VSS VSS sky130_fd_pr__nfet_01v8 l=1 w=40 m=2
XM4 X D1 VSS VSS sky130_fd_pr__nfet_01v8 l=1 w=40 m=2
XMB NB NB VIN VIN sky130_fd_pr__pfet_01v8 l=0.5 w=100 m=1
XMD G G VIN VIN sky130_fd_pr__pfet_01v8 l=0.15 w=15 m=1
XMN2 G X VSS VSS sky130_fd_pr__nfet_01v8 l=0.5 w=20 m=1
XMP VOUT G VIN VIN sky130_fd_pr__pfet_01v8 l=0.15 w=100 m=6
XMT TAIL NB TS VIN sky130_fd_pr__pfet_01v8 l=0.5 w=100 m=6
.ends DUT
