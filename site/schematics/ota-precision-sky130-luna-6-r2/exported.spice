.subckt DUT VINP VINN VOUT VDD VSS IBIAS
CCOMP NDIFFN NCOMP 5.6p
RCOMP NCOMP VOUT 85k
XINN NDIFFP VINN NTAIL VSS sky130_fd_pr__nfet_01v8 l=2 w=80 m=1
XINP NDIFFN VINP NTAIL VSS sky130_fd_pr__nfet_01v8 l=2 w=78.4 m=1
XLOAD1 NDIFFP NDIFFP VDD VDD sky130_fd_pr__pfet_01v8 l=2 w=80 m=1
XLOAD2 NDIFFN NDIFFP VDD VDD sky130_fd_pr__pfet_01v8 l=2 w=80 m=1
XOUTN VOUT NDIFFN VSS VSS sky130_fd_pr__nfet_01v8 l=4 w=2 m=1
XOUTP VOUT IBIAS VDD VDD sky130_fd_pr__pfet_01v8 l=1 w=25 m=1
XREFN IBIAS IBIAS VSS VSS sky130_fd_pr__nfet_01v8 l=1 w=4 m=1
XTAIL NTAIL IBIAS VSS VSS sky130_fd_pr__nfet_01v8 l=2 w=4 m=1
.ends DUT
