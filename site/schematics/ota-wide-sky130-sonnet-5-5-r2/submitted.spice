* OTA v4b: complementary input, N pair folded via PMOS sources+cascodes (replica-biased cascode gate) into shared NMOS mirror
.subckt DUT VINP VINN VOUT VDD VSS IBIAS
XMB0 IBIAS IBIAS VSS VSS sky130_fd_pr__nfet_01v8 W=20 L=1 nf=1 m=1
XMTN TN IBIAS VSS VSS sky130_fd_pr__nfet_01v8 W=60 L=1 nf=1 m=1
XMBP PB IBIAS VSS VSS sky130_fd_pr__nfet_01v8 W=20 L=1 nf=1 m=1
XMPB PB PB VDD VDD sky130_fd_pr__pfet_01v8 W=40 L=1 nf=1 m=1
XMTP TP PB VDD VDD sky130_fd_pr__pfet_01v8 W=80 L=1 nf=1 m=1
XM10 VOUT PB VDD VDD sky130_fd_pr__pfet_01v8 W=100 L=1 nf=1 m=4
* cascode gate bias replica: VB = VDD - Vsg - Ib*Rx
XMD GD GD VDD VDD sky130_fd_pr__pfet_01v8 W=40 L=0.5 nf=1 m=1
RX GD VB 30000
XMBV VB IBIAS VSS VSS sky130_fd_pr__nfet_01v8 W=16 L=1 nf=1 m=1
CB VB VDD 2p
XM1 F1 VINN TN VSS sky130_fd_pr__nfet_01v8 W=80 L=0.5 nf=1 m=1
XM2 F2 VINP TN VSS sky130_fd_pr__nfet_01v8 W=80 L=0.5 nf=1 m=1
XMS1 F1 PB VDD VDD sky130_fd_pr__pfet_01v8 W=96 L=1 nf=1 m=1
XMS2 F2 PB VDD VDD sky130_fd_pr__pfet_01v8 W=96 L=1 nf=1 m=1
XMC1 D2 VB F1 VDD sky130_fd_pr__pfet_01v8 W=40 L=0.5 nf=1 m=1
XMC2 X VB F2 VDD sky130_fd_pr__pfet_01v8 W=40 L=0.5 nf=1 m=1
XM3 D2 VINN TP VDD sky130_fd_pr__pfet_01v8 W=100 L=0.5 nf=1 m=1
XM4 X VINP TP VDD sky130_fd_pr__pfet_01v8 W=100 L=0.5 nf=1 m=1
XM7 D2 D2 VSS VSS sky130_fd_pr__nfet_01v8 W=50 L=1 nf=1 m=1
XM8 X D2 VSS VSS sky130_fd_pr__nfet_01v8 W=50 L=1 nf=1 m=1
XM9 VOUT X VSS VSS sky130_fd_pr__nfet_01v8 W=100 L=0.5 nf=1 m=2
RZ X CZ 1k
CC CZ VOUT 4p
.ends DUT
