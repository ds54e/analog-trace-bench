.subckt DUT VIN VOUT VSS VREF
CCOMP NOUT VSS 0.001p
CFF VOUT VGATE 29.8p
RBIASG VIN VGATE 100k
RBIASN VIN NBIAS 100k
RFBIAS VIN FBIN 186k
RFBOT VFB VSS 47k
RFSIG VFB FBIN 100k
RFTOP VOUT VFB 23k
RLOADFB VIN NOUT 100k
RLOADREF VIN NREF 100k
RRBIAS VIN REFIN 650k
RRSIG VREF REFIN 560k
XNBIAS NBIAS NBIAS VSS VSS sky130_fd_pr__nfet_01v8 l=2 w=10 nf=1 m=1
XNFB NOUT FBIN NTAIL VSS sky130_fd_pr__nfet_01v8 l=0.25 w=100 nf=1 m=1
XNGATE VGATE NOUT VSS VSS sky130_fd_pr__nfet_01v8 l=0.15 w=100 nf=1 m=8
XNREF NREF REFIN NTAIL VSS sky130_fd_pr__nfet_01v8 l=0.25 w=100 nf=1 m=1
XNTAIL NTAIL NBIAS VSS VSS sky130_fd_pr__nfet_01v8 l=2 w=20 nf=1 m=1
XPASS VOUT VGATE VIN VIN sky130_fd_pr__pfet_01v8 l=0.15 w=100 nf=1 m=32
XPDRV VGATE NOUT VIN VIN sky130_fd_pr__pfet_01v8 l=0.5 w=100 nf=1 m=1
.ends DUT
