* Symmetric two-stage OTA with resistive common-mode feedback
.subckt DUT VINP VINN VOUT VDD VSS IBIAS
* Reference and separate tail sinks
XREF IBIAS IBIAS VSS VSS sky130_fd_pr__nfet_01v8 w=20 l=2 m=1
XTAIL1 T1 IBIAS VSS VSS sky130_fd_pr__nfet_01v8 w=40 l=2 m=1
XTAIL2 T2 IBIAS VSS VSS sky130_fd_pr__nfet_01v8 w=100 l=2 m=1
* First differential stage: the resistors form a common-mode servo
XN1 A VINN T1 VSS sky130_fd_pr__nfet_01v8 w=100 l=2 m=2
XN2 B VINP T1 VSS sky130_fd_pr__nfet_01v8 w=100 l=2 m=2
XP1 A PG VDD VDD sky130_fd_pr__pfet_01v8 w=100 l=2 m=6
XP2 B PG VDD VDD sky130_fd_pr__pfet_01v8 w=100 l=2 m=6
RCM1 A CM 5meg
RCM2 B CM 5meg
RSHIFT CM PG 25meg
RBASE PG VSS 75meg
RSWG1 IBIAS SWG 50meg
RSWG2 SWG VSS 50meg
XSW PG SWG CM VDD sky130_fd_pr__pfet_01v8 w=50 l=1 m=1
* Second differential stage with active load, directly drives output
XN3 M2 A T2 VSS sky130_fd_pr__nfet_01v8 w=100 l=2 m=2
XN4 VOUT B T2 VSS sky130_fd_pr__nfet_01v8 w=100 l=2 m=2
XP3 M2 M2 VDD VDD sky130_fd_pr__pfet_01v8 w=75 l=3.75 m=1
XP4 VOUT M2 VDD VDD sky130_fd_pr__pfet_01v8 w=75 l=3.75 m=1
RZ B NC 7k
CC NC VOUT 10p
CA A VSS 10p
.ends DUT
