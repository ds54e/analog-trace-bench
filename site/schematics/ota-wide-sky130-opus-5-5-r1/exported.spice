.subckt DUT VINP VINN VOUT VDD VSS IBIAS
CC CZ VOUT 4p
CF VBPO VDD 1.5p
RF VBP1 VBPO 300k
RN YN VSS 30k
RP VDD XP 30k
RZ C2 CZ 1.2k
XMDN VBNC VBNC YN VSS sky130_fd_pr__nfet_01v8 l=0.5 w=7 m=1
XMDP VBPC VBPC XP VDD sky130_fd_pr__pfet_01v8 l=0.15 w=16 m=1
XMN1 B1 C1 VSS VSS sky130_fd_pr__nfet_01v8 l=2 w=20 m=1
XMN2 B2 C1 VSS VSS sky130_fd_pr__nfet_01v8 l=2 w=20 m=1
XMN3 C1 VBNC B1 VSS sky130_fd_pr__nfet_01v8 l=0.5 w=20 m=1
XMN4 C2 VBNC B2 VSS sky130_fd_pr__nfet_01v8 l=0.5 w=20 m=1
XMNB0 IBIAS IBIAS VSS VSS sky130_fd_pr__nfet_01v8 l=1 w=20 m=1
XMNIN A1 VINN TN VSS sky130_fd_pr__nfet_01v8 l=1 w=40 m=3
XMNIP A2 VINP TN VSS sky130_fd_pr__nfet_01v8 l=1 w=40 m=3
XMNS1 VBP1 IBIAS VSS VSS sky130_fd_pr__nfet_01v8 l=1 w=20 m=1
XMNS2 VBP2 IBIAS VSS VSS sky130_fd_pr__nfet_01v8 l=1 w=20 m=1
XMNS3 VBPC IBIAS VSS VSS sky130_fd_pr__nfet_01v8 l=1 w=20 m=1
XMNT TN IBIAS VSS VSS sky130_fd_pr__nfet_01v8 l=1 w=20 m=2
XMO1 VOUT C2 VSS VSS sky130_fd_pr__nfet_01v8 l=1 w=50 m=1
XMO2 VOUT VBPO VDD VDD sky130_fd_pr__pfet_01v8 l=0.5 w=20 m=15
XMP1 A1 VBP2 VDD VDD sky130_fd_pr__pfet_01v8 l=0.5 w=10 m=3
XMP2 A2 VBP2 VDD VDD sky130_fd_pr__pfet_01v8 l=0.5 w=10 m=3
XMP3 C1 VBPC A1 VDD sky130_fd_pr__pfet_01v8 l=0.15 w=40 m=1
XMP4 C2 VBPC A2 VDD sky130_fd_pr__pfet_01v8 l=0.15 w=40 m=1
XMPB1 VBP1 VBP1 VDD VDD sky130_fd_pr__pfet_01v8 l=0.5 w=20 m=1
XMPB2 VBP2 VBP2 VDD VDD sky130_fd_pr__pfet_01v8 l=0.5 w=10 m=1
XMPIN B1 VINN TP VDD sky130_fd_pr__pfet_01v8 l=0.15 w=100 m=6
XMPIP B2 VINP TP VDD sky130_fd_pr__pfet_01v8 l=0.15 w=100 m=6
XMPS1 VBNC VBP1 VDD VDD sky130_fd_pr__pfet_01v8 l=0.5 w=20 m=1
XMPT TP VBP1 VDD VDD sky130_fd_pr__pfet_01v8 l=0.5 w=20 m=2
.ends DUT
