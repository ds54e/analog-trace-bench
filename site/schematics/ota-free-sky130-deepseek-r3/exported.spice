.subckt DUT VINP VINN VOUT VDD VSS IBIAS
CC Z VOUT 2.25e-12
R1 NB2 ND 62000
R3 PBP PD 45000
RZ N2 Z 3000
XM_B1 IBIAS IBIAS VSS VSS sky130_fd_pr__nfet_01v8 l=2 w=34
XM_B2 NB2 VBP VDD VDD sky130_fd_pr__pfet_01v8 l=1.2 w=50
XM_B3 ND ND VSS VSS sky130_fd_pr__nfet_01v8 l=2 w=34
XM_B4 PD IBIAS VSS VSS sky130_fd_pr__nfet_01v8 l=2 w=34
XM_B5 PBP PBP VDD VDD sky130_fd_pr__pfet_01v8 l=1.2 w=50
XM_B6 VBP VBP VDD VDD sky130_fd_pr__pfet_01v8 l=1.2 w=50
XM_B7 VBP IBIAS VSS VSS sky130_fd_pr__nfet_01v8 l=2 w=34
XM0 T IBIAS VSS VSS sky130_fd_pr__nfet_01v8 l=1.2 w=100
XM1 A VINN T VSS sky130_fd_pr__nfet_01v8 l=1 w=60
XM10 VOUT IBIAS VSS VSS sky130_fd_pr__nfet_01v8 l=0.15 w=100 m=2
XM2 B VINP T VSS sky130_fd_pr__nfet_01v8 l=1 w=60
XM3 C1 N1 VDD VDD sky130_fd_pr__pfet_01v8 l=0.3 w=100
XM4 C2 N1 VDD VDD sky130_fd_pr__pfet_01v8 l=0.3 w=100
XM5 N1 PD C1 VDD sky130_fd_pr__pfet_01v8 l=0.3 w=100
XM6 N2 PD C2 VDD sky130_fd_pr__pfet_01v8 l=0.3 w=100
XM7 N1 NB2 A VSS sky130_fd_pr__nfet_01v8 l=2 w=44
XM8 N2 NB2 B VSS sky130_fd_pr__nfet_01v8 l=2 w=44
XM9 VOUT N2 VDD VDD sky130_fd_pr__pfet_01v8 l=0.3 w=100
.ends DUT
