* v10 {"R1": 12000.0, "R2": 12000.0, "W1": 100, "L1": 4, "M1": 3, "RT": 3200.0, "W3": 40, "L3": 0.5, "RX": 300000.0, "WQ": 36.0, "LQ": 0.5, "WR": 5.0, "LR": 1, "MN": 8.0, "WD": 100.0, "LD": 0.15, "WP": 100, "LP": 0.15, "MP": 32, "CFF": 0, "CG": 0, "RXON": 0.0, "MP2": 32.0, "RDD": 5000.0, "RQ": 3000.0, "MD": 2.0, "MP3": 0}
.subckt DUT VIN VOUT VSS VREF
R1 VOUT FB 12000
R2 FB VSS 12000
XM1 D1 FB S VSS sky130_fd_pr__nfet_01v8 W=100 L=4 nf=1 m=3
XM2 X VREF S VSS sky130_fd_pr__nfet_01v8 W=100 L=4 nf=1 m=3
RT S VSS 3200
XM3 D1 D1 VIN VIN sky130_fd_pr__pfet_01v8 W=40 L=0.5 nf=1 m=1
XM4 X D1 VIN VIN sky130_fd_pr__pfet_01v8 W=40 L=0.5 nf=1 m=1
XMQ Y X SQ VIN sky130_fd_pr__pfet_01v8 W=36 L=0.5 nf=1 m=1
RQ VIN SQ 3000
XMR Y Y VSS VSS sky130_fd_pr__nfet_01v8 W=5 L=1 nf=1 m=1
XMN G Y VSS VSS sky130_fd_pr__nfet_01v8 W=5 L=1 nf=1 m=8
XMD GD G VIN VIN sky130_fd_pr__pfet_01v8 W=100 L=0.15 nf=1 m=2
RDD GD G 5000
XMP VOUT G VIN VIN sky130_fd_pr__pfet_01v8 W=100 L=0.15 nf=1 m=32
XMP2 VOUT G VIN VIN sky130_fd_pr__pfet_01v8 W=100 L=0.15 nf=1 m=32
.ends DUT
