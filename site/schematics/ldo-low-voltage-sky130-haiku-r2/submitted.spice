* LDO v9: PMOS-input error amp, NMOS common-source gate driver, PMOS pull-up current source, parallel pass devices
.subckt DUT VIN VOUT VSS VREF
RF1 VOUT FB 50k
RF2 FB VSS 50k
RBP BP VSS 200k
XMP6 BP BP VIN VIN sky130_fd_pr__pfet_01v8 W=2 L=1 nf=1 m=1
XMP5 TAILP BP VIN VIN sky130_fd_pr__pfet_01v8 W=64 L=1 nf=1 m=1
XMP1 ND1 VREF TAILP VIN sky130_fd_pr__pfet_01v8 W=20 L=0.15 nf=1 m=1
XMP2 N1 FB TAILP VIN sky130_fd_pr__pfet_01v8 W=20 L=0.15 nf=1 m=1
XMN3 ND1 ND1 VSS VSS sky130_fd_pr__nfet_01v8 W=10 L=0.15 nf=1 m=1
XMN4 N1 ND1 VSS VSS sky130_fd_pr__nfet_01v8 W=10 L=0.15 nf=1 m=1
XMPU G BP VIN VIN sky130_fd_pr__pfet_01v8 W=64 L=1 nf=1 m=1
XMB G N1 VSS VSS sky130_fd_pr__nfet_01v8 W=20 L=0.15 nf=1 m=1
XMP VOUT G VIN VIN sky130_fd_pr__pfet_01v8 W=100 L=0.15 nf=1 m=1
.ends DUT
