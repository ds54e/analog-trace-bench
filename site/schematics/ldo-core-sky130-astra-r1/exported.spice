.subckt DUT VIN VOUT VSS VREF
CCOMP CM GATE 0.3p
CFF VOUT FB 1p
CREF REF VREF 5p
CREFAC RAC REF 2.2p
RBIAS VIN BIAS 150k
RCOMP VOUT CM 50k
RFB1 VOUT FB 149k
RFB2 FB VSS 151.013513513514k
RFB3 VIN FB 175k
RREF1 VIN REF 1.4meg
RREF2 REF VREF 600k
RREFAC VIN RAC 40k
XNBIAS BIAS BIAS VSS VSS sky130_fd_pr__nfet_01v8 l=1 w=10 nf=1 m=1
XNFB N1 FB TAIL VSS sky130_fd_pr__nfet_01v8 l=1 w=40 nf=1 m=1
XNREF GATE REF TAIL VSS sky130_fd_pr__nfet_01v8 l=1 w=40 nf=1 m=1
XNTAIL TAIL BIAS VSS VSS sky130_fd_pr__nfet_01v8 l=1 w=30 nf=1 m=1
XP1 N1 N1 VIN VIN sky130_fd_pr__pfet_01v8 l=0.5 w=40 nf=1 m=1
XP2 GATE N1 VIN VIN sky130_fd_pr__pfet_01v8 l=0.5 w=40 nf=1 m=1
XPPASS VOUT GATE VIN VIN sky130_fd_pr__pfet_01v8 l=0.15 w=100 nf=1 m=3
.ends DUT
