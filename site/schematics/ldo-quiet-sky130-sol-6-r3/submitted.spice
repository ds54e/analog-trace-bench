* Low-voltage NMOS-input regulator with a PMOS mirror load.
.subckt DUT VIN VOUT VSS VREF
RFB1 VOUT FB 99.2k
RFB2 FB VSS 100k
CFB VOUT FB 80p

* Reference-derived tail bias.
RREF VREF NB 350k
XNB NB NB VSS VSS sky130_fd_pr__nfet_01v8 w=100 l=0.15 m=1
XTAIL ST NB VSS VSS sky130_fd_pr__nfet_01v8 w=100 l=0.15 m=32
XTAIL2 ST NB VSS VSS sky130_fd_pr__nfet_01v8 w=100 l=0.15 m=32

* NMOS differential pair, PMOS mirror, direct gate drive.
XNFB P1 FB ST VSS sky130_fd_pr__nfet_01v8 w=100 l=0.5 m=6
XNREF PG VREF ST VSS sky130_fd_pr__nfet_01v8 w=100 l=0.5 m=6
XP1 P1 P1 VIN VIN sky130_fd_pr__pfet_01v8 w=100 l=1 m=4
XP2 PG P1 VIN VIN sky130_fd_pr__pfet_01v8 w=100 l=1 m=4
XPASS VOUT PG VIN VIN sky130_fd_pr__pfet_01v8 w=100 l=0.15 m=6
CFF VIN PG 2p
.ends DUT
