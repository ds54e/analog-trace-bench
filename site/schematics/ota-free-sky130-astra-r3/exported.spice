.subckt DUT VINP VINN VOUT VDD VSS IBIAS
CC NC VOUT 2.2p
RZ N2 NC 2200
XINN N1 VINN NT VSS sky130_fd_pr__nfet_01v8 l=1 w=60 nf=1 m=1
XINP N2 VINP NT VSS sky130_fd_pr__nfet_01v8 l=1 w=60 nf=1 m=1
XOUTN VOUT IBIAS VSS VSS sky130_fd_pr__nfet_01v8 l=1 w=64 nf=1 m=1
XOUTP VOUT N2 VDD VDD sky130_fd_pr__pfet_01v8 l=0.5 w=100 nf=1 m=2
XPL1 N1 N1 VDD VDD sky130_fd_pr__pfet_01v8 l=0.5 w=25 nf=1 m=1
XPL2 N2 N1 VDD VDD sky130_fd_pr__pfet_01v8 l=0.5 w=25 nf=1 m=1
XREF IBIAS IBIAS VSS VSS sky130_fd_pr__nfet_01v8 l=1 w=4 nf=1 m=1
XTAIL NT IBIAS VSS VSS sky130_fd_pr__nfet_01v8 l=1 w=16 nf=1 m=1
.ends DUT
