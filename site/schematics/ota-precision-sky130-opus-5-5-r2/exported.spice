.subckt DUT VINP VINN VOUT VDD VSS IBIAS
CC VOUT CZ 12p
RZ CZ X 2.5k
XM0 TAIL IBIAS VSS VSS sky130_fd_pr__nfet_01v8 l=2 w=40 m=4
XM1 F1 VINN TAIL VSS sky130_fd_pr__nfet_01v8 l=2 w=50 m=4
XM10 VOUT VBP VDD VDD sky130_fd_pr__pfet_01v8 l=4 w=50 m=2
XM2 F2 VINP TAIL VSS sky130_fd_pr__nfet_01v8 l=2 w=50 m=4
XM3 F1 VBP VDD VDD sky130_fd_pr__pfet_01v8 l=4 w=60 m=1
XM4 F2 VBP VDD VDD sky130_fd_pr__pfet_01v8 l=4 w=60 m=1
XM5 D1 VBP2 F1 VDD sky130_fd_pr__pfet_01v8 l=1 w=20 m=1
XM6 X VBP2 F2 VDD sky130_fd_pr__pfet_01v8 l=1 w=20 m=1
XM7 S7 D1 VSS VSS sky130_fd_pr__nfet_01v8 l=4 w=10 m=1
XM7C D1 VBN2 S7 VSS sky130_fd_pr__nfet_01v8 l=1 w=20 m=1
XM8 S8 D1 VSS VSS sky130_fd_pr__nfet_01v8 l=4 w=10 m=1
XM8C X VBN2 S8 VSS sky130_fd_pr__nfet_01v8 l=1 w=20 m=1
XM9 VOUT X VSS VSS sky130_fd_pr__nfet_01v8 l=1 w=40 m=1
XMNB1 VBP2 IBIAS VSS VSS sky130_fd_pr__nfet_01v8 l=2 w=20 m=1
XMNB2 VBN2 VBN2 VSS VSS sky130_fd_pr__nfet_01v8 l=2 w=1 m=1
XMNP VBP IBIAS VSS VSS sky130_fd_pr__nfet_01v8 l=2 w=40 m=1
XMNREF IBIAS IBIAS VSS VSS sky130_fd_pr__nfet_01v8 l=2 w=40 m=1
XMPB2 VBP2 VBP2 VDD VDD sky130_fd_pr__pfet_01v8 l=1.25 w=1 m=1
XMPD VBP VBP VDD VDD sky130_fd_pr__pfet_01v8 l=4 w=20 m=1
XMPX VBN2 VBP VDD VDD sky130_fd_pr__pfet_01v8 l=4 w=10 m=1
.ends DUT
