.subckt DUT VIN VOUT VSS VREF
R1 VOUT FB 60000.0
R2 FB VSS 60000.0
CFF VOUT FB 2e-12
XM1 D1 VREF S VSS sky130_fd_pr__nfet_01v8 W=100 L=1 nf=1 m=2
XM2 E FB S VSS sky130_fd_pr__nfet_01v8 W=100 L=1 nf=1 m=2
RT S VSS 3300.0
XM3 D1 D1 VIN VIN sky130_fd_pr__pfet_01v8 W=4 L=0.5 nf=1 m=1
XM4 E D1 VIN VIN sky130_fd_pr__pfet_01v8 W=4 L=0.5 nf=1 m=1
RC E EC 23000.0
CC EC VSS 5e-12
XM5 G E VSS VSS sky130_fd_pr__nfet_01v8 W=10 L=0.5 nf=1 m=1
XM6 G G S6 VIN sky130_fd_pr__pfet_01v8 W=6.4 L=0.15 nf=1 m=1
RS6 VIN S6 3000
XMP VOUT G VIN VIN sky130_fd_pr__pfet_01v8 W=40 L=0.15 nf=1 m=8
CS6 VIN S6 1e-11
.ends DUT
