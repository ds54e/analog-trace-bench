* LDO: tail-less NMOS pair, PMOS mirror load, direct-drive PMOS pass
.subckt DUT VIN VOUT VSS VREF
XMA DA VFB VSS VSS sky130_fd_pr__nfet_01v8 W=64 L=4 nf=1 m=1
XMB X VREF VSS VSS sky130_fd_pr__nfet_01v8 W=49 L=3 nf=1 m=1
XMC DA DA VIN VIN sky130_fd_pr__pfet_01v8 W=70 L=3 nf=1 m=1
XMD X DA VIN VIN sky130_fd_pr__pfet_01v8 W=70 L=3 nf=1 m=1
XMP VOUT X VIN VIN sky130_fd_pr__pfet_01v8 W=100 L=0.15 nf=1 m=2
R1 VOUT VFB 20k
R2 VFB VSS 20k
.ends DUT
