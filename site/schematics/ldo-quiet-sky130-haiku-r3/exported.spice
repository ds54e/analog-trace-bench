.subckt DUT VIN VOUT VSS VREF
R1 VOUT VFB 20k
R2 VFB VSS 20k
XMA DA VFB VSS VSS sky130_fd_pr__nfet_01v8 l=4 w=64 nf=1 m=1
XMB X VREF VSS VSS sky130_fd_pr__nfet_01v8 l=3 w=49 nf=1 m=1
XMC DA DA VIN VIN sky130_fd_pr__pfet_01v8 l=3 w=70 nf=1 m=1
XMD X DA VIN VIN sky130_fd_pr__pfet_01v8 l=3 w=70 nf=1 m=1
XMP VOUT X VIN VIN sky130_fd_pr__pfet_01v8 l=0.15 w=100 nf=1 m=2
.ends DUT
