.subckt DUT VINP VINN VOUT VDD VSS IBIAS
CC NC VOUT 2.5p
RZ N2 NC 1500
XINN N2 VINP TAIL VSS sky130_fd_pr__nfet_01v8 l=1 w=60 nf=1 m=1
XINP N1 VINN TAIL VSS sky130_fd_pr__nfet_01v8 l=1 w=60 nf=1 m=1
XOUTN VOUT IBIAS VSS VSS sky130_fd_pr__nfet_01v8 l=1 w=85 nf=1 m=4
XOUTP VOUT N2 VDD VDD sky130_fd_pr__pfet_01v8 l=0.5 w=80 nf=1 m=2
XPM1 N1 N1 VDD VDD sky130_fd_pr__pfet_01v8 l=0.5 w=32 nf=1 m=1
XPM2 N2 N1 VDD VDD sky130_fd_pr__pfet_01v8 l=0.5 w=32 nf=1 m=1
XREF IBIAS IBIAS VSS VSS sky130_fd_pr__nfet_01v8 l=1 w=20 nf=1 m=1
XTAIL TAIL IBIAS VSS VSS sky130_fd_pr__nfet_01v8 l=1 w=70 nf=1 m=2
.ends DUT
