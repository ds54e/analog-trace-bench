* LDO-CORE-SKY130: cascoded PMOS-input OTA -> PI (Rz+Cz) -> NMOS transconductor
* -> diode-connected PMOS, 1:N current mirror to PMOS pass device. Divider doubles as bleeder.
.subckt DUT VIN VOUT VSS VREF
* bias: VIN-referenced NMOS diode (single DC solution), mirrored to PMOS diode
RA VIN NBN 920000
XMBN NBN NBN VSS VSS sky130_fd_pr__nfet_01v8 W=2 L=1 nf=1 m=1
XMBN2 NB NBN VSS VSS sky130_fd_pr__nfet_01v8 W=2 L=1 nf=1 m=1
XMB1 NB NB VIN VIN sky130_fd_pr__pfet_01v8 W=4 L=1 nf=1 m=1
* error amplifier: PMOS input pair, PMOS cascodes (gates at VSS), NMOS mirror load
XMT NT NB VIN VIN sky130_fd_pr__pfet_01v8 W=4 L=1 nf=1 m=12
XM1 X1 VREF NT VIN sky130_fd_pr__pfet_01v8 W=60 L=0.15 nf=1 m=1
XM2 X2 FB NT VIN sky130_fd_pr__pfet_01v8 W=60 L=0.15 nf=1 m=1
XM7 N1 VSS X1 VIN sky130_fd_pr__pfet_01v8 W=20 L=0.18 nf=1 m=1
XM8 NA VSS X2 VIN sky130_fd_pr__pfet_01v8 W=20 L=0.18 nf=1 m=1
XM3 N1 N1 VSS VSS sky130_fd_pr__nfet_01v8 W=3 L=0.75 nf=1 m=1
XM4 NA N1 VSS VSS sky130_fd_pr__nfet_01v8 W=3 L=0.75 nf=1 m=1
* PI compensation at the error-amplifier output
RZ NA NZ 130000
CZ NZ VSS 1.1e-12
* transconductor into diode-connected PMOS that mirrors 1:N to the pass device
XMN G NA VSS VSS sky130_fd_pr__nfet_01v8 W=6 L=0.15 nf=1 m=1
XMD G G VIN VIN sky130_fd_pr__pfet_01v8 W=1.25 L=0.15 nf=1 m=1
XMP VOUT G VIN VIN sky130_fd_pr__pfet_01v8 W=50 L=0.15 nf=1 m=3
* feedback divider (VOUT = 2*VREF), also light-load bleeder
R1 VOUT FB 25000
R2 FB VSS 25000
CFF VOUT FB 2e-13
.ends DUT
