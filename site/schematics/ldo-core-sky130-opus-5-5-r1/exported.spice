.subckt DUT VIN VOUT VSS VREF
CFF VOUT FB 2e-13
CZ NZ VSS 1.1e-12
R1 VOUT FB 25000
R2 FB VSS 25000
RA VIN NBN 920000
RZ NA NZ 130000
XM1 X1 VREF NT VIN sky130_fd_pr__pfet_01v8 l=0.15 w=60 nf=1 m=1
XM2 X2 FB NT VIN sky130_fd_pr__pfet_01v8 l=0.15 w=60 nf=1 m=1
XM3 N1 N1 VSS VSS sky130_fd_pr__nfet_01v8 l=0.75 w=3 nf=1 m=1
XM4 NA N1 VSS VSS sky130_fd_pr__nfet_01v8 l=0.75 w=3 nf=1 m=1
XM7 N1 VSS X1 VIN sky130_fd_pr__pfet_01v8 l=0.18 w=20 nf=1 m=1
XM8 NA VSS X2 VIN sky130_fd_pr__pfet_01v8 l=0.18 w=20 nf=1 m=1
XMB1 NB NB VIN VIN sky130_fd_pr__pfet_01v8 l=1 w=4 nf=1 m=1
XMBN NBN NBN VSS VSS sky130_fd_pr__nfet_01v8 l=1 w=2 nf=1 m=1
XMBN2 NB NBN VSS VSS sky130_fd_pr__nfet_01v8 l=1 w=2 nf=1 m=1
XMD G G VIN VIN sky130_fd_pr__pfet_01v8 l=0.15 w=1.25 nf=1 m=1
XMN G NA VSS VSS sky130_fd_pr__nfet_01v8 l=0.15 w=6 nf=1 m=1
XMP VOUT G VIN VIN sky130_fd_pr__pfet_01v8 l=0.15 w=50 nf=1 m=3
XMT NT NB VIN VIN sky130_fd_pr__pfet_01v8 l=1 w=4 nf=1 m=12
.ends DUT
