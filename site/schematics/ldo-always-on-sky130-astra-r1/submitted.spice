* NMOS-input error amplifier and PMOS series pass element.
.subckt DUT VIN VOUT VSS VREF
RFBT VOUT FB 1.98meg
RFBB FB VSS 2meg
CFF VOUT FB 1p
RBIAS VIN NB 4.7meg
XNBIAS NB NB VSS VSS sky130_fd_pr__nfet_01v8 w=4 l=2 nf=1 m=1
XNTAIL TAIL NB VSS VSS sky130_fd_pr__nfet_01v8 w=8 l=2 nf=1 m=1
XNIN1 N1 FB TAIL VSS sky130_fd_pr__nfet_01v8 w=20 l=0.5 nf=1 m=1
XNIN2 GATE VREF TAIL VSS sky130_fd_pr__nfet_01v8 w=20 l=0.5 nf=1 m=1
XPM1 N1 N1 VIN VIN sky130_fd_pr__pfet_01v8 w=1 l=1 nf=1 m=1
XPM2 GATE N1 VIN VIN sky130_fd_pr__pfet_01v8 w=1 l=1 nf=1 m=1
XPPASS VOUT GATE VIN VIN sky130_fd_pr__pfet_01v8 w=20 l=0.15 nf=1 m=1
.ends DUT
