* folded-cascode OTA, NMOS input pair, wide-swing NMOS mirror load
.subckt DUT VINP VINN VOUT VDD VSS IBIAS
* bias references
XMB0 IBIAS IBIAS VSS VSS sky130_fd_pr__nfet_01v8 W=30 L=2 nf=1 m=1
XM5 TAIL IBIAS VSS VSS sky130_fd_pr__nfet_01v8 W=30 L=2 nf=1 m=4
XMNP0 VBP IBIAS VSS VSS sky130_fd_pr__nfet_01v8 W=30 L=2 nf=1 m=1
XMNPB VBPC IBIAS VSS VSS sky130_fd_pr__nfet_01v8 W=30 L=2 nf=1 m=1
XMP0 VBP VBP VDD VDD sky130_fd_pr__pfet_01v8 W=39 L=3 nf=1 m=1
XMPB VBPC VBPC SB VDD sky130_fd_pr__pfet_01v8 W=80 L=2 nf=1 m=1
RPB VDD SB 45000
XMPBN VBNC VBP VDD VDD sky130_fd_pr__pfet_01v8 W=39 L=3 nf=1 m=1
XMNB3 VBNC VBNC RBT VSS sky130_fd_pr__nfet_01v8 W=90 L=3 nf=1 m=1
RB RBT VSS 45000
* input pair: M1 (left, VINP) M2 (output side, VINN)
XM1 F1 VINP TAIL VSS sky130_fd_pr__nfet_01v8 W=62.5 L=2.5 nf=1 m=4
XM2 F2 VINN TAIL VSS sky130_fd_pr__nfet_01v8 W=62.5 L=2.5 nf=1 m=4
* PMOS sources and cascodes
XMS1 F1 VBP VDD VDD sky130_fd_pr__pfet_01v8 W=60 L=3 nf=1 m=3
XMS2 F2 VBP VDD VDD sky130_fd_pr__pfet_01v8 W=60 L=3 nf=1 m=3
XMC1 A VBPC F1 VDD sky130_fd_pr__pfet_01v8 W=80 L=2 nf=1 m=1
XMC2 VOUT VBPC F2 VDD sky130_fd_pr__pfet_01v8 W=80 L=2 nf=1 m=1
* wide-swing NMOS cascode mirror
XMQ3 A VBNC E1 VSS sky130_fd_pr__nfet_01v8 W=90 L=3 nf=1 m=1
XMQ4 VOUT VBNC E2 VSS sky130_fd_pr__nfet_01v8 W=90 L=3 nf=1 m=1
XMQ1 E1 A VSS VSS sky130_fd_pr__nfet_01v8 W=60 L=5 nf=1 m=1
XMQ2 E2 A VSS VSS sky130_fd_pr__nfet_01v8 W=60 L=5 nf=1 m=1
CEXT VOUT VSS 6e-12
.ends DUT
