.subckt DUT VIN VOUT VSS VREF
RB VIN VB 130k
RBOT FB VSS 100k
RTOP VOUT FB 100k
XM1 D1 FB VT VSS sky130_fd_pr__nfet_01v8 l=0.5 w=2.5 nf=1 m=1
XM2 VA VREF VT VSS sky130_fd_pr__nfet_01v8 l=0.5 w=2.5 nf=1 m=1
XM3 D1 D1 VIN VIN sky130_fd_pr__pfet_01v8 l=0.5 w=16 nf=1 m=1
XM4 VA D1 VIN VIN sky130_fd_pr__pfet_01v8 l=0.5 w=16 nf=1 m=1
XMB VB VB VSS VSS sky130_fd_pr__nfet_01v8 l=0.5 w=4 nf=1 m=1
XMF VIN VA VG VSS sky130_fd_pr__nfet_01v8 l=0.15 w=10 nf=1 m=1
XMFS VG VB VSS VSS sky130_fd_pr__nfet_01v8 l=0.5 w=6 nf=1 m=1
XMP VOUT VG VIN VIN sky130_fd_pr__pfet_01v8 l=0.15 w=30 nf=1 m=1
XMT VT VB VSS VSS sky130_fd_pr__nfet_01v8 l=0.5 w=8 nf=1 m=1
.ends DUT
