.subckt DUT VIN VOUT VSS VREF
XMP VOUT PG VIN VIN sky130_fd_pr__pfet_01v8 w=100 l=0.5 m=16
RFBT VOUT FB 51184.834
RFF VIN FB 3600000
RFBB FB VSS 50000
XMBIAS PB PB VIN VIN sky130_fd_pr__pfet_01v8 w=5 l=1 m=1
RBIAS PB VSS 60000
XMTAIL TAIL PB VIN VIN sky130_fd_pr__pfet_01v8 w=10 l=1 m=1
RNB VOUT BN 75000
XNREF BN BN VSS VSS sky130_fd_pr__nfet_01v8 w=100 l=0.15 m=16
XNBIAS PB2 BN VSS VSS sky130_fd_pr__nfet_01v8 w=100 l=0.15 m=12
XPBIAS2 PB2 PB2 VIN VIN sky130_fd_pr__pfet_01v8 w=5 l=1 m=1
XPTAIL2 TAIL PB2 VIN VIN sky130_fd_pr__pfet_01v8 w=10 l=1 m=1
XMPFB ND FB TAIL VIN sky130_fd_pr__pfet_01v8 w=100 l=0.5 m=24
XMPREF PG VREF TAIL VIN sky130_fd_pr__pfet_01v8 w=100 l=0.5 m=24
XMND ND ND NSD VSS sky130_fd_pr__nfet_01v8 w=100 l=2 m=4
XMNG PG ND NSG VSS sky130_fd_pr__nfet_01v8 w=100 l=2 m=4

RSD NSD VSS 3000
RSG NSG VSS 3000
CCOMP PG CZ 5p
RZ CZ VOUT 800000
CFB VOUT FB 95p
.ends DUT
