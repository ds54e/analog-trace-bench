.subckt DUT VIN VOUT VSS VREF
CCOMP PG CZ 5p
CFB VOUT FB 95p
RBIAS PB VSS 60000
RFBB FB VSS 50000
RFBT VOUT FB 51184.834
RFF VIN FB 3600000
RNB VOUT BN 75000
RSD NSD VSS 3000
RSG NSG VSS 3000
RZ CZ VOUT 800000
XMBIAS PB PB VIN VIN sky130_fd_pr__pfet_01v8 l=1 w=5 m=1
XMND ND ND NSD VSS sky130_fd_pr__nfet_01v8 l=2 w=100 m=4
XMNG PG ND NSG VSS sky130_fd_pr__nfet_01v8 l=2 w=100 m=4
XMP VOUT PG VIN VIN sky130_fd_pr__pfet_01v8 l=0.5 w=100 m=16
XMPFB ND FB TAIL VIN sky130_fd_pr__pfet_01v8 l=0.5 w=100 m=24
XMPREF PG VREF TAIL VIN sky130_fd_pr__pfet_01v8 l=0.5 w=100 m=24
XMTAIL TAIL PB VIN VIN sky130_fd_pr__pfet_01v8 l=1 w=10 m=1
XNBIAS PB2 BN VSS VSS sky130_fd_pr__nfet_01v8 l=0.15 w=100 m=12
XNREF BN BN VSS VSS sky130_fd_pr__nfet_01v8 l=0.15 w=100 m=16
XPBIAS2 PB2 PB2 VIN VIN sky130_fd_pr__pfet_01v8 l=1 w=5 m=1
XPTAIL2 TAIL PB2 VIN VIN sky130_fd_pr__pfet_01v8 l=1 w=10 m=1
.ends DUT
