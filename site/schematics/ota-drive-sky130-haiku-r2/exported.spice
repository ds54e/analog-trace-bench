.subckt DUT VINP VINN VOUT VDD VSS IBIAS
CC O1 NZ 10p
RZ NZ VOUT 700
XM1 N1 VINN NT VSS sky130_fd_pr__nfet_01v8 l=0.5 w=100 nf=1 m=1
XM2 O1 VINP NT VSS sky130_fd_pr__nfet_01v8 l=0.5 w=100 nf=1 m=1
XM3 N1 N1 VDD VDD sky130_fd_pr__pfet_01v8 l=0.6 w=100 nf=1 m=1
XM4 O1 N1 VDD VDD sky130_fd_pr__pfet_01v8 l=0.6 w=100 nf=1 m=1
XM6 VOUT O1 VDD VDD sky130_fd_pr__pfet_01v8 l=0.3 w=100 nf=1 m=8
XM7 VOUT IBIAS VSS VSS sky130_fd_pr__nfet_01v8 l=1 w=100 nf=1 m=20
XMB IBIAS IBIAS VSS VSS sky130_fd_pr__nfet_01v8 l=1 w=20 nf=1 m=1
XMT NT IBIAS VSS VSS sky130_fd_pr__nfet_01v8 l=1 w=100 nf=1 m=5
.ends DUT
