* Two-stage Miller OTA: NMOS pair, PMOS mirror load, PMOS common-source output, NMOS sink
.subckt DUT VINP VINN VOUT VDD VSS IBIAS
XMB IBIAS IBIAS VSS VSS sky130_fd_pr__nfet_01v8 W=40 L=2 nf=1 m=1
XMT TAIL IBIAS VSS VSS sky130_fd_pr__nfet_01v8 W=80 L=2 nf=1 m=1
XM7 VOUT IBIAS VSS VSS sky130_fd_pr__nfet_01v8 W=80 L=2 nf=1 m=4
XM1 ND1 VINN TAIL VSS sky130_fd_pr__nfet_01v8 W=40 L=4 nf=1 m=1
XM2 N1 VINP TAIL VSS sky130_fd_pr__nfet_01v8 W=40 L=4 nf=1 m=1
XM3 ND1 ND1 VDD VDD sky130_fd_pr__pfet_01v8 W=80 L=2 nf=1 m=1
XM4 N1 ND1 VDD VDD sky130_fd_pr__pfet_01v8 W=80 L=2 nf=1 m=1
XM6 VOUT N1 VDD VDD sky130_fd_pr__pfet_01v8 W=80 L=2 nf=1 m=8
RZ N1 NZ 3k
CC NZ VOUT 4.0p
.ends DUT
