* Two-stage Miller OTA: NMOS pair, PMOS mirror load, PMOS common-source output, NMOS sink, nulling-resistor compensation
.subckt DUT VINP VINN VOUT VDD VSS IBIAS
XMB IBIAS IBIAS VSS VSS sky130_fd_pr__nfet_01v8 W=10 L=1 nf=1 m=1
XMT TAIL IBIAS VSS VSS sky130_fd_pr__nfet_01v8 W=80 L=1 nf=1 m=1
XMN1 DIO VINN TAIL VSS sky130_fd_pr__nfet_01v8 W=40 L=1 nf=1 m=1
XMN2 X VINP TAIL VSS sky130_fd_pr__nfet_01v8 W=40 L=1 nf=1 m=1
XMP3 DIO DIO VDD VDD sky130_fd_pr__pfet_01v8 W=60 L=1 nf=1 m=1
XMP4 X DIO VDD VDD sky130_fd_pr__pfet_01v8 W=60 L=1 nf=1 m=1
XMP6 VOUT X VDD VDD sky130_fd_pr__pfet_01v8 W=80 L=0.5 nf=1 m=5
XMN7 VOUT IBIAS VSS VSS sky130_fd_pr__nfet_01v8 W=80 L=1 nf=1 m=10
RZ X NZ 2200
CC NZ VOUT 4p
.ends DUT
